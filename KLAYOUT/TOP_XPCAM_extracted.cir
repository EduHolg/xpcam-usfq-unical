* Extracted by KLayout with SG13G2 LVS runset on : 23/03/2026 23:00

.SUBCKT TOP_XPCAM VSS PC Veval CLK OUT_FIN VDD C B A EN_DEC IN EN
M$1 VSS \$5 \$4 VSS sg13_lv_nmos L=0.13u W=2.96u AS=1.0064p AD=1.0064p PS=6.6u
+ PD=6.6u
M$2 VSS \$8 \$3 VSS sg13_lv_nmos L=0.13u W=2.96u AS=1.0064p AD=1.0064p PS=6.6u
+ PD=6.6u
M$3 VSS Veval \$8 VSS sg13_lv_nmos L=0.13u W=0.74u AS=0.2516p AD=0.2516p
+ PS=2.16u PD=2.16u
M$4 VSS \$3 \$5 VSS sg13_lv_nmos L=0.13u W=0.74u AS=0.2516p AD=0.2516p PS=2.16u
+ PD=2.16u
M$5 \$239 \$5 \$9 VSS sg13_lv_nmos L=0.13u W=0.74u AS=0.2516p AD=0.2516p
+ PS=2.16u PD=2.16u
M$6 VSS \$9 \$10 VSS sg13_lv_nmos L=0.13u W=0.74u AS=0.2516p AD=0.2516p
+ PS=2.16u PD=2.16u
M$7 VSS \$10 \$11 VSS sg13_lv_nmos L=0.13u W=0.74u AS=0.2516p AD=0.2516p
+ PS=2.16u PD=2.16u
M$8 \$9 \$4 \$12 VSS sg13_lv_nmos L=0.13u W=0.74u AS=0.2516p AD=0.2516p
+ PS=2.16u PD=2.16u
M$9 \$12 \$10 VSS VSS sg13_lv_nmos L=0.13u W=0.74u AS=0.2516p AD=0.2516p
+ PS=2.16u PD=2.16u
M$10 VSS Veval \$38 VSS sg13_lv_nmos L=0.13u W=0.74u AS=0.2516p AD=0.2516p
+ PS=2.16u PD=2.16u
M$11 VSS \$38 \$30 VSS sg13_lv_nmos L=0.13u W=2.96u AS=1.0064p AD=1.0064p
+ PS=6.6u PD=6.6u
M$12 VSS \$30 \$35 VSS sg13_lv_nmos L=0.13u W=0.74u AS=0.2516p AD=0.2516p
+ PS=2.16u PD=2.16u
M$13 VSS \$35 \$31 VSS sg13_lv_nmos L=0.13u W=2.96u AS=1.0064p AD=1.0064p
+ PS=6.6u PD=6.6u
M$14 \$443 \$35 \$39 VSS sg13_lv_nmos L=0.13u W=0.74u AS=0.2516p AD=0.2516p
+ PS=2.16u PD=2.16u
M$15 VSS \$39 \$40 VSS sg13_lv_nmos L=0.13u W=0.74u AS=0.2516p AD=0.2516p
+ PS=2.16u PD=2.16u
M$16 VSS \$40 \$41 VSS sg13_lv_nmos L=0.13u W=0.74u AS=0.2516p AD=0.2516p
+ PS=2.16u PD=2.16u
M$17 \$39 \$31 \$42 VSS sg13_lv_nmos L=0.13u W=0.74u AS=0.2516p AD=0.2516p
+ PS=2.16u PD=2.16u
M$18 \$42 \$40 VSS VSS sg13_lv_nmos L=0.13u W=0.74u AS=0.2516p AD=0.2516p
+ PS=2.16u PD=2.16u
M$19 VSS \$11 \$52 VSS sg13_lv_nmos L=0.13u W=0.74u AS=0.2516p AD=0.1406p
+ PS=2.16u PD=1.12u
M$20 \$52 \$32 \$53 VSS sg13_lv_nmos L=0.13u W=0.74u AS=0.1406p AD=0.1406p
+ PS=1.12u PD=1.12u
M$21 \$53 CLK \$54 VSS sg13_lv_nmos L=0.13u W=0.74u AS=0.1406p AD=0.1406p
+ PS=1.12u PD=1.12u
M$22 \$54 \$55 VSS VSS sg13_lv_nmos L=0.13u W=0.74u AS=0.1406p AD=0.2516p
+ PS=1.12u PD=2.16u
M$23 VSS \$53 \$55 VSS sg13_lv_nmos L=0.13u W=0.74u AS=0.2516p AD=0.1406p
+ PS=2.16u PD=1.12u
M$24 \$55 CLK \$56 VSS sg13_lv_nmos L=0.13u W=0.74u AS=0.1406p AD=0.1406p
+ PS=1.12u PD=1.12u
M$25 \$56 \$32 \$57 VSS sg13_lv_nmos L=0.13u W=0.74u AS=0.1406p AD=0.1406p
+ PS=1.12u PD=1.12u
M$26 \$57 \$58 VSS VSS sg13_lv_nmos L=0.13u W=0.74u AS=0.1406p AD=0.2516p
+ PS=1.12u PD=2.16u
M$27 VSS \$56 \$58 VSS sg13_lv_nmos L=0.13u W=0.74u AS=0.2516p AD=0.2516p
+ PS=2.16u PD=2.16u
M$28 VSS \$58 \$59 VSS sg13_lv_nmos L=0.13u W=0.74u AS=0.2516p AD=0.2516p
+ PS=2.16u PD=2.16u
M$29 VSS CLK \$32 VSS sg13_lv_nmos L=0.13u W=0.74u AS=0.2516p AD=0.2516p
+ PS=2.16u PD=2.16u
M$30 VSS \$71 \$60 VSS sg13_lv_nmos L=0.13u W=0.74u AS=0.2516p AD=0.1406p
+ PS=2.16u PD=1.12u
M$31 \$60 \$34 \$61 VSS sg13_lv_nmos L=0.13u W=0.74u AS=0.1406p AD=0.1406p
+ PS=1.12u PD=1.12u
M$32 \$61 CLK \$62 VSS sg13_lv_nmos L=0.13u W=0.74u AS=0.1406p AD=0.1406p
+ PS=1.12u PD=1.12u
M$33 \$62 \$63 VSS VSS sg13_lv_nmos L=0.13u W=0.74u AS=0.1406p AD=0.2516p
+ PS=1.12u PD=2.16u
M$34 VSS \$61 \$63 VSS sg13_lv_nmos L=0.13u W=0.74u AS=0.2516p AD=0.1406p
+ PS=2.16u PD=1.12u
M$35 \$63 CLK \$64 VSS sg13_lv_nmos L=0.13u W=0.74u AS=0.1406p AD=0.1406p
+ PS=1.12u PD=1.12u
M$36 \$64 \$34 \$65 VSS sg13_lv_nmos L=0.13u W=0.74u AS=0.1406p AD=0.1406p
+ PS=1.12u PD=1.12u
M$37 \$65 \$66 VSS VSS sg13_lv_nmos L=0.13u W=0.74u AS=0.1406p AD=0.2516p
+ PS=1.12u PD=2.16u
M$38 VSS \$64 \$66 VSS sg13_lv_nmos L=0.13u W=0.74u AS=0.2516p AD=0.2516p
+ PS=2.16u PD=2.16u
M$39 VSS \$66 OUT_FIN VSS sg13_lv_nmos L=0.13u W=0.74u AS=0.2516p AD=0.2516p
+ PS=2.16u PD=2.16u
M$40 VSS CLK \$34 VSS sg13_lv_nmos L=0.13u W=0.74u AS=0.2516p AD=0.2516p
+ PS=2.16u PD=2.16u
M$41 VSS \$41 \$144 VSS sg13_lv_nmos L=0.13u W=0.74u AS=0.2516p AD=0.1406p
+ PS=2.16u PD=1.12u
M$42 \$144 \$140 \$145 VSS sg13_lv_nmos L=0.13u W=0.74u AS=0.1406p AD=0.1406p
+ PS=1.12u PD=1.12u
M$43 \$145 CLK \$146 VSS sg13_lv_nmos L=0.13u W=0.74u AS=0.1406p AD=0.1406p
+ PS=1.12u PD=1.12u
M$44 \$146 \$147 VSS VSS sg13_lv_nmos L=0.13u W=0.74u AS=0.1406p AD=0.2516p
+ PS=1.12u PD=2.16u
M$45 VSS \$145 \$147 VSS sg13_lv_nmos L=0.13u W=0.74u AS=0.2516p AD=0.1406p
+ PS=2.16u PD=1.12u
M$46 \$147 CLK \$148 VSS sg13_lv_nmos L=0.13u W=0.74u AS=0.1406p AD=0.1406p
+ PS=1.12u PD=1.12u
M$47 \$148 \$140 \$149 VSS sg13_lv_nmos L=0.13u W=0.74u AS=0.1406p AD=0.1406p
+ PS=1.12u PD=1.12u
M$48 \$149 \$150 VSS VSS sg13_lv_nmos L=0.13u W=0.74u AS=0.1406p AD=0.2516p
+ PS=1.12u PD=2.16u
M$49 VSS \$148 \$150 VSS sg13_lv_nmos L=0.13u W=0.74u AS=0.2516p AD=0.2516p
+ PS=2.16u PD=2.16u
M$50 VSS \$150 \$151 VSS sg13_lv_nmos L=0.13u W=0.74u AS=0.2516p AD=0.2516p
+ PS=2.16u PD=2.16u
M$51 VSS CLK \$140 VSS sg13_lv_nmos L=0.13u W=0.74u AS=0.2516p AD=0.2516p
+ PS=2.16u PD=2.16u
M$52 VSS \$100 \$68 VSS sg13_lv_nmos L=0.13u W=0.74u AS=0.2516p AD=0.2516p
+ PS=2.16u PD=2.16u
M$53 \$69 \$59 VSS VSS sg13_lv_nmos L=0.13u W=0.74u AS=0.2516p AD=0.1406p
+ PS=2.16u PD=1.12u
M$54 VSS \$33 \$44 VSS sg13_lv_nmos L=0.13u W=0.74u AS=0.1406p AD=0.2516p
+ PS=1.12u PD=2.16u
M$55 \$69 \$100 \$70 VSS sg13_lv_nmos L=0.13u W=0.74u AS=0.2516p AD=0.1406p
+ PS=2.16u PD=1.12u
M$56 \$70 \$68 \$44 VSS sg13_lv_nmos L=0.13u W=0.74u AS=0.1406p AD=0.2516p
+ PS=1.12u PD=2.16u
M$57 VSS \$70 \$71 VSS sg13_lv_nmos L=0.13u W=0.74u AS=0.2516p AD=0.2516p
+ PS=2.16u PD=2.16u
M$58 VSS \$164 \$152 VSS sg13_lv_nmos L=0.13u W=0.74u AS=0.2516p AD=0.1406p
+ PS=2.16u PD=1.12u
M$59 \$152 \$142 \$153 VSS sg13_lv_nmos L=0.13u W=0.74u AS=0.1406p AD=0.1406p
+ PS=1.12u PD=1.12u
M$60 \$153 CLK \$154 VSS sg13_lv_nmos L=0.13u W=0.74u AS=0.1406p AD=0.1406p
+ PS=1.12u PD=1.12u
M$61 \$154 \$155 VSS VSS sg13_lv_nmos L=0.13u W=0.74u AS=0.1406p AD=0.2516p
+ PS=1.12u PD=2.16u
M$62 VSS \$153 \$155 VSS sg13_lv_nmos L=0.13u W=0.74u AS=0.2516p AD=0.1406p
+ PS=2.16u PD=1.12u
M$63 \$155 CLK \$156 VSS sg13_lv_nmos L=0.13u W=0.74u AS=0.1406p AD=0.1406p
+ PS=1.12u PD=1.12u
M$64 \$156 \$142 \$157 VSS sg13_lv_nmos L=0.13u W=0.74u AS=0.1406p AD=0.1406p
+ PS=1.12u PD=1.12u
M$65 \$157 \$158 VSS VSS sg13_lv_nmos L=0.13u W=0.74u AS=0.1406p AD=0.2516p
+ PS=1.12u PD=2.16u
M$66 VSS \$156 \$158 VSS sg13_lv_nmos L=0.13u W=0.74u AS=0.2516p AD=0.2516p
+ PS=2.16u PD=2.16u
M$67 VSS \$158 \$33 VSS sg13_lv_nmos L=0.13u W=0.74u AS=0.2516p AD=0.2516p
+ PS=2.16u PD=2.16u
M$68 VSS CLK \$142 VSS sg13_lv_nmos L=0.13u W=0.74u AS=0.2516p AD=0.2516p
+ PS=2.16u PD=2.16u
M$69 VSS \$238 \$255 VSS sg13_lv_nmos L=0.13u W=0.74u AS=0.2516p AD=0.33115p
+ PS=2.16u PD=1.635u
M$70 \$255 \$247 \$256 VSS sg13_lv_nmos L=0.13u W=0.74u AS=0.33115p AD=0.33115p
+ PS=1.635u PD=1.635u
M$71 \$256 \$255 \$257 VSS sg13_lv_nmos L=0.13u W=0.74u AS=0.33115p AD=0.33115p
+ PS=1.635u PD=1.635u
M$72 \$257 \$238 \$258 VSS sg13_lv_nmos L=0.13u W=0.74u AS=0.33115p AD=0.33115p
+ PS=1.635u PD=1.635u
M$73 \$258 \$247 \$238 VSS sg13_lv_nmos L=0.13u W=0.74u AS=0.33115p AD=0.2516p
+ PS=1.635u PD=2.16u
M$74 \$239 \$257 \$259 VSS sg13_lv_nmos L=0.13u W=0.74u AS=0.2516p AD=0.33115p
+ PS=2.16u PD=1.635u
M$75 \$259 Veval VSS VSS sg13_lv_nmos L=0.13u W=0.74u AS=0.33115p AD=0.2516p
+ PS=1.635u PD=2.16u
M$76 \$238 \$255 VSS VSS sg13_lv_nmos L=0.13u W=0.74u AS=0.2516p AD=0.2516p
+ PS=2.16u PD=2.16u
M$77 VSS \$240 \$260 VSS sg13_lv_nmos L=0.13u W=0.74u AS=0.2516p AD=0.33115p
+ PS=2.16u PD=1.635u
M$78 \$260 \$247 \$261 VSS sg13_lv_nmos L=0.13u W=0.74u AS=0.33115p AD=0.33115p
+ PS=1.635u PD=1.635u
M$79 \$261 \$260 \$262 VSS sg13_lv_nmos L=0.13u W=0.74u AS=0.33115p AD=0.33115p
+ PS=1.635u PD=1.635u
M$80 \$262 \$240 \$263 VSS sg13_lv_nmos L=0.13u W=0.74u AS=0.33115p AD=0.33115p
+ PS=1.635u PD=1.635u
M$81 \$263 \$247 \$240 VSS sg13_lv_nmos L=0.13u W=0.74u AS=0.33115p AD=0.2516p
+ PS=1.635u PD=2.16u
M$82 \$239 \$262 \$264 VSS sg13_lv_nmos L=0.13u W=0.74u AS=0.2516p AD=0.33115p
+ PS=2.16u PD=1.635u
M$83 \$264 Veval VSS VSS sg13_lv_nmos L=0.13u W=0.74u AS=0.33115p AD=0.2516p
+ PS=1.635u PD=2.16u
M$84 \$240 \$260 VSS VSS sg13_lv_nmos L=0.13u W=0.74u AS=0.2516p AD=0.2516p
+ PS=2.16u PD=2.16u
M$85 VSS \$241 \$265 VSS sg13_lv_nmos L=0.13u W=0.74u AS=0.2516p AD=0.33115p
+ PS=2.16u PD=1.635u
M$86 \$265 \$247 \$266 VSS sg13_lv_nmos L=0.13u W=0.74u AS=0.33115p AD=0.33115p
+ PS=1.635u PD=1.635u
M$87 \$266 \$265 \$267 VSS sg13_lv_nmos L=0.13u W=0.74u AS=0.33115p AD=0.33115p
+ PS=1.635u PD=1.635u
M$88 \$267 \$241 \$268 VSS sg13_lv_nmos L=0.13u W=0.74u AS=0.33115p AD=0.33115p
+ PS=1.635u PD=1.635u
M$89 \$268 \$247 \$241 VSS sg13_lv_nmos L=0.13u W=0.74u AS=0.33115p AD=0.2516p
+ PS=1.635u PD=2.16u
M$90 \$239 \$267 \$269 VSS sg13_lv_nmos L=0.13u W=0.74u AS=0.2516p AD=0.33115p
+ PS=2.16u PD=1.635u
M$91 \$269 Veval VSS VSS sg13_lv_nmos L=0.13u W=0.74u AS=0.33115p AD=0.2516p
+ PS=1.635u PD=2.16u
M$92 \$241 \$265 VSS VSS sg13_lv_nmos L=0.13u W=0.74u AS=0.2516p AD=0.2516p
+ PS=2.16u PD=2.16u
M$93 VSS \$242 \$270 VSS sg13_lv_nmos L=0.13u W=0.74u AS=0.2516p AD=0.33115p
+ PS=2.16u PD=1.635u
M$94 \$270 \$247 \$271 VSS sg13_lv_nmos L=0.13u W=0.74u AS=0.33115p AD=0.33115p
+ PS=1.635u PD=1.635u
M$95 \$271 \$270 \$272 VSS sg13_lv_nmos L=0.13u W=0.74u AS=0.33115p AD=0.33115p
+ PS=1.635u PD=1.635u
M$96 \$272 \$242 \$273 VSS sg13_lv_nmos L=0.13u W=0.74u AS=0.33115p AD=0.33115p
+ PS=1.635u PD=1.635u
M$97 \$273 \$247 \$242 VSS sg13_lv_nmos L=0.13u W=0.74u AS=0.33115p AD=0.2516p
+ PS=1.635u PD=2.16u
M$98 \$239 \$272 \$274 VSS sg13_lv_nmos L=0.13u W=0.74u AS=0.2516p AD=0.33115p
+ PS=2.16u PD=1.635u
M$99 \$274 Veval VSS VSS sg13_lv_nmos L=0.13u W=0.74u AS=0.33115p AD=0.2516p
+ PS=1.635u PD=2.16u
M$100 \$242 \$270 VSS VSS sg13_lv_nmos L=0.13u W=0.74u AS=0.2516p AD=0.2516p
+ PS=2.16u PD=2.16u
M$101 VSS \$243 \$275 VSS sg13_lv_nmos L=0.13u W=0.74u AS=0.2516p AD=0.33115p
+ PS=2.16u PD=1.635u
M$102 \$275 \$247 \$276 VSS sg13_lv_nmos L=0.13u W=0.74u AS=0.33115p
+ AD=0.33115p PS=1.635u PD=1.635u
M$103 \$276 \$275 \$277 VSS sg13_lv_nmos L=0.13u W=0.74u AS=0.33115p
+ AD=0.33115p PS=1.635u PD=1.635u
M$104 \$277 \$243 \$278 VSS sg13_lv_nmos L=0.13u W=0.74u AS=0.33115p
+ AD=0.33115p PS=1.635u PD=1.635u
M$105 \$278 \$247 \$243 VSS sg13_lv_nmos L=0.13u W=0.74u AS=0.33115p AD=0.2516p
+ PS=1.635u PD=2.16u
M$106 \$239 \$277 \$279 VSS sg13_lv_nmos L=0.13u W=0.74u AS=0.2516p AD=0.33115p
+ PS=2.16u PD=1.635u
M$107 \$279 Veval VSS VSS sg13_lv_nmos L=0.13u W=0.74u AS=0.33115p AD=0.2516p
+ PS=1.635u PD=2.16u
M$108 \$243 \$275 VSS VSS sg13_lv_nmos L=0.13u W=0.74u AS=0.2516p AD=0.2516p
+ PS=2.16u PD=2.16u
M$109 VSS \$244 \$280 VSS sg13_lv_nmos L=0.13u W=0.74u AS=0.2516p AD=0.33115p
+ PS=2.16u PD=1.635u
M$110 \$280 \$247 \$281 VSS sg13_lv_nmos L=0.13u W=0.74u AS=0.33115p
+ AD=0.33115p PS=1.635u PD=1.635u
M$111 \$281 \$280 \$282 VSS sg13_lv_nmos L=0.13u W=0.74u AS=0.33115p
+ AD=0.33115p PS=1.635u PD=1.635u
M$112 \$282 \$244 \$283 VSS sg13_lv_nmos L=0.13u W=0.74u AS=0.33115p
+ AD=0.33115p PS=1.635u PD=1.635u
M$113 \$283 \$247 \$244 VSS sg13_lv_nmos L=0.13u W=0.74u AS=0.33115p AD=0.2516p
+ PS=1.635u PD=2.16u
M$114 \$239 \$282 \$284 VSS sg13_lv_nmos L=0.13u W=0.74u AS=0.2516p AD=0.33115p
+ PS=2.16u PD=1.635u
M$115 \$284 Veval VSS VSS sg13_lv_nmos L=0.13u W=0.74u AS=0.33115p AD=0.2516p
+ PS=1.635u PD=2.16u
M$116 \$244 \$280 VSS VSS sg13_lv_nmos L=0.13u W=0.74u AS=0.2516p AD=0.2516p
+ PS=2.16u PD=2.16u
M$117 VSS \$245 \$285 VSS sg13_lv_nmos L=0.13u W=0.74u AS=0.2516p AD=0.33115p
+ PS=2.16u PD=1.635u
M$118 \$285 \$247 \$286 VSS sg13_lv_nmos L=0.13u W=0.74u AS=0.33115p
+ AD=0.33115p PS=1.635u PD=1.635u
M$119 \$286 \$285 \$287 VSS sg13_lv_nmos L=0.13u W=0.74u AS=0.33115p
+ AD=0.33115p PS=1.635u PD=1.635u
M$120 \$287 \$245 \$288 VSS sg13_lv_nmos L=0.13u W=0.74u AS=0.33115p
+ AD=0.33115p PS=1.635u PD=1.635u
M$121 \$288 \$247 \$245 VSS sg13_lv_nmos L=0.13u W=0.74u AS=0.33115p AD=0.2516p
+ PS=1.635u PD=2.16u
M$122 \$239 \$287 \$289 VSS sg13_lv_nmos L=0.13u W=0.74u AS=0.2516p AD=0.33115p
+ PS=2.16u PD=1.635u
M$123 \$289 Veval VSS VSS sg13_lv_nmos L=0.13u W=0.74u AS=0.33115p AD=0.2516p
+ PS=1.635u PD=2.16u
M$124 \$245 \$285 VSS VSS sg13_lv_nmos L=0.13u W=0.74u AS=0.2516p AD=0.2516p
+ PS=2.16u PD=2.16u
M$125 VSS \$246 \$290 VSS sg13_lv_nmos L=0.13u W=0.74u AS=0.2516p AD=0.33115p
+ PS=2.16u PD=1.635u
M$126 \$290 \$247 \$291 VSS sg13_lv_nmos L=0.13u W=0.74u AS=0.33115p
+ AD=0.33115p PS=1.635u PD=1.635u
M$127 \$291 \$290 \$292 VSS sg13_lv_nmos L=0.13u W=0.74u AS=0.33115p
+ AD=0.33115p PS=1.635u PD=1.635u
M$128 \$292 \$246 \$293 VSS sg13_lv_nmos L=0.13u W=0.74u AS=0.33115p
+ AD=0.33115p PS=1.635u PD=1.635u
M$129 \$293 \$247 \$246 VSS sg13_lv_nmos L=0.13u W=0.74u AS=0.33115p AD=0.2516p
+ PS=1.635u PD=2.16u
M$130 \$239 \$292 \$294 VSS sg13_lv_nmos L=0.13u W=0.74u AS=0.2516p AD=0.33115p
+ PS=2.16u PD=1.635u
M$131 \$294 Veval VSS VSS sg13_lv_nmos L=0.13u W=0.74u AS=0.33115p AD=0.2516p
+ PS=1.635u PD=2.16u
M$132 \$246 \$290 VSS VSS sg13_lv_nmos L=0.13u W=0.74u AS=0.2516p AD=0.2516p
+ PS=2.16u PD=2.16u
M$133 VSS Veval \$226 VSS sg13_lv_nmos L=0.13u W=0.74u AS=0.2516p AD=0.2516p
+ PS=2.16u PD=2.16u
M$134 VSS \$226 \$159 VSS sg13_lv_nmos L=0.13u W=2.96u AS=1.0064p AD=1.0064p
+ PS=6.6u PD=6.6u
M$135 VSS \$159 \$193 VSS sg13_lv_nmos L=0.13u W=0.74u AS=0.2516p AD=0.2516p
+ PS=2.16u PD=2.16u
M$136 VSS \$193 \$160 VSS sg13_lv_nmos L=0.13u W=2.96u AS=1.0064p AD=1.0064p
+ PS=6.6u PD=6.6u
M$137 \$647 \$193 \$227 VSS sg13_lv_nmos L=0.13u W=0.74u AS=0.2516p AD=0.2516p
+ PS=2.16u PD=2.16u
M$138 VSS \$227 \$228 VSS sg13_lv_nmos L=0.13u W=0.74u AS=0.2516p AD=0.2516p
+ PS=2.16u PD=2.16u
M$139 VSS \$228 \$229 VSS sg13_lv_nmos L=0.13u W=0.74u AS=0.2516p AD=0.2516p
+ PS=2.16u PD=2.16u
M$140 \$227 \$160 \$230 VSS sg13_lv_nmos L=0.13u W=0.74u AS=0.2516p AD=0.2516p
+ PS=2.16u PD=2.16u
M$141 \$230 \$228 VSS VSS sg13_lv_nmos L=0.13u W=0.74u AS=0.2516p AD=0.2516p
+ PS=2.16u PD=2.16u
M$142 VSS \$100 \$161 VSS sg13_lv_nmos L=0.13u W=0.74u AS=0.2516p AD=0.2516p
+ PS=2.16u PD=2.16u
M$143 \$162 \$151 VSS VSS sg13_lv_nmos L=0.13u W=0.74u AS=0.2516p AD=0.1406p
+ PS=2.16u PD=1.12u
M$144 VSS \$141 \$143 VSS sg13_lv_nmos L=0.13u W=0.74u AS=0.1406p AD=0.2516p
+ PS=1.12u PD=2.16u
M$145 \$162 \$100 \$163 VSS sg13_lv_nmos L=0.13u W=0.74u AS=0.2516p AD=0.1406p
+ PS=2.16u PD=1.12u
M$146 \$163 \$161 \$143 VSS sg13_lv_nmos L=0.13u W=0.74u AS=0.1406p AD=0.2516p
+ PS=1.12u PD=2.16u
M$147 VSS \$163 \$164 VSS sg13_lv_nmos L=0.13u W=0.74u AS=0.2516p AD=0.2516p
+ PS=2.16u PD=2.16u
M$148 \$247 \$385 VSS VSS sg13_lv_nmos L=0.13u W=0.74u AS=0.3663p AD=0.2516p
+ PS=2.47u PD=2.16u
M$149 VSS C \$403 VSS sg13_lv_nmos L=0.13u W=0.74u AS=0.2516p AD=0.33115p
+ PS=2.16u PD=1.635u
M$150 \$403 B \$438 VSS sg13_lv_nmos L=0.13u W=0.74u AS=0.33115p AD=0.33115p
+ PS=1.635u PD=1.635u
M$151 \$438 A \$385 VSS sg13_lv_nmos L=0.13u W=0.74u AS=0.33115p AD=0.2516p
+ PS=1.635u PD=2.16u
M$152 VSS \$442 \$484 VSS sg13_lv_nmos L=0.13u W=0.74u AS=0.2516p AD=0.33115p
+ PS=2.16u PD=1.635u
M$153 \$484 \$483 \$256 VSS sg13_lv_nmos L=0.13u W=0.74u AS=0.33115p
+ AD=0.33115p PS=1.635u PD=1.635u
M$154 \$256 \$484 \$485 VSS sg13_lv_nmos L=0.13u W=0.74u AS=0.33115p
+ AD=0.33115p PS=1.635u PD=1.635u
M$155 \$485 \$442 \$258 VSS sg13_lv_nmos L=0.13u W=0.74u AS=0.33115p
+ AD=0.33115p PS=1.635u PD=1.635u
M$156 \$258 \$483 \$442 VSS sg13_lv_nmos L=0.13u W=0.74u AS=0.33115p AD=0.2516p
+ PS=1.635u PD=2.16u
M$157 \$443 \$485 \$486 VSS sg13_lv_nmos L=0.13u W=0.74u AS=0.2516p AD=0.33115p
+ PS=2.16u PD=1.635u
M$158 \$486 Veval VSS VSS sg13_lv_nmos L=0.13u W=0.74u AS=0.33115p AD=0.2516p
+ PS=1.635u PD=2.16u
M$159 \$442 \$484 VSS VSS sg13_lv_nmos L=0.13u W=0.74u AS=0.2516p AD=0.2516p
+ PS=2.16u PD=2.16u
M$160 VSS \$444 \$487 VSS sg13_lv_nmos L=0.13u W=0.74u AS=0.2516p AD=0.33115p
+ PS=2.16u PD=1.635u
M$161 \$487 \$483 \$261 VSS sg13_lv_nmos L=0.13u W=0.74u AS=0.33115p
+ AD=0.33115p PS=1.635u PD=1.635u
M$162 \$261 \$487 \$488 VSS sg13_lv_nmos L=0.13u W=0.74u AS=0.33115p
+ AD=0.33115p PS=1.635u PD=1.635u
M$163 \$488 \$444 \$263 VSS sg13_lv_nmos L=0.13u W=0.74u AS=0.33115p
+ AD=0.33115p PS=1.635u PD=1.635u
M$164 \$263 \$483 \$444 VSS sg13_lv_nmos L=0.13u W=0.74u AS=0.33115p AD=0.2516p
+ PS=1.635u PD=2.16u
M$165 \$443 \$488 \$489 VSS sg13_lv_nmos L=0.13u W=0.74u AS=0.2516p AD=0.33115p
+ PS=2.16u PD=1.635u
M$166 \$489 Veval VSS VSS sg13_lv_nmos L=0.13u W=0.74u AS=0.33115p AD=0.2516p
+ PS=1.635u PD=2.16u
M$167 \$444 \$487 VSS VSS sg13_lv_nmos L=0.13u W=0.74u AS=0.2516p AD=0.2516p
+ PS=2.16u PD=2.16u
M$168 VSS \$445 \$490 VSS sg13_lv_nmos L=0.13u W=0.74u AS=0.2516p AD=0.33115p
+ PS=2.16u PD=1.635u
M$169 \$490 \$483 \$266 VSS sg13_lv_nmos L=0.13u W=0.74u AS=0.33115p
+ AD=0.33115p PS=1.635u PD=1.635u
M$170 \$266 \$490 \$491 VSS sg13_lv_nmos L=0.13u W=0.74u AS=0.33115p
+ AD=0.33115p PS=1.635u PD=1.635u
M$171 \$491 \$445 \$268 VSS sg13_lv_nmos L=0.13u W=0.74u AS=0.33115p
+ AD=0.33115p PS=1.635u PD=1.635u
M$172 \$268 \$483 \$445 VSS sg13_lv_nmos L=0.13u W=0.74u AS=0.33115p AD=0.2516p
+ PS=1.635u PD=2.16u
M$173 \$443 \$491 \$492 VSS sg13_lv_nmos L=0.13u W=0.74u AS=0.2516p AD=0.33115p
+ PS=2.16u PD=1.635u
M$174 \$492 Veval VSS VSS sg13_lv_nmos L=0.13u W=0.74u AS=0.33115p AD=0.2516p
+ PS=1.635u PD=2.16u
M$175 \$445 \$490 VSS VSS sg13_lv_nmos L=0.13u W=0.74u AS=0.2516p AD=0.2516p
+ PS=2.16u PD=2.16u
M$176 VSS \$446 \$493 VSS sg13_lv_nmos L=0.13u W=0.74u AS=0.2516p AD=0.33115p
+ PS=2.16u PD=1.635u
M$177 \$493 \$483 \$271 VSS sg13_lv_nmos L=0.13u W=0.74u AS=0.33115p
+ AD=0.33115p PS=1.635u PD=1.635u
M$178 \$271 \$493 \$494 VSS sg13_lv_nmos L=0.13u W=0.74u AS=0.33115p
+ AD=0.33115p PS=1.635u PD=1.635u
M$179 \$494 \$446 \$273 VSS sg13_lv_nmos L=0.13u W=0.74u AS=0.33115p
+ AD=0.33115p PS=1.635u PD=1.635u
M$180 \$273 \$483 \$446 VSS sg13_lv_nmos L=0.13u W=0.74u AS=0.33115p AD=0.2516p
+ PS=1.635u PD=2.16u
M$181 \$443 \$494 \$495 VSS sg13_lv_nmos L=0.13u W=0.74u AS=0.2516p AD=0.33115p
+ PS=2.16u PD=1.635u
M$182 \$495 Veval VSS VSS sg13_lv_nmos L=0.13u W=0.74u AS=0.33115p AD=0.2516p
+ PS=1.635u PD=2.16u
M$183 \$446 \$493 VSS VSS sg13_lv_nmos L=0.13u W=0.74u AS=0.2516p AD=0.2516p
+ PS=2.16u PD=2.16u
M$184 VSS \$447 \$496 VSS sg13_lv_nmos L=0.13u W=0.74u AS=0.2516p AD=0.33115p
+ PS=2.16u PD=1.635u
M$185 \$496 \$483 \$276 VSS sg13_lv_nmos L=0.13u W=0.74u AS=0.33115p
+ AD=0.33115p PS=1.635u PD=1.635u
M$186 \$276 \$496 \$497 VSS sg13_lv_nmos L=0.13u W=0.74u AS=0.33115p
+ AD=0.33115p PS=1.635u PD=1.635u
M$187 \$497 \$447 \$278 VSS sg13_lv_nmos L=0.13u W=0.74u AS=0.33115p
+ AD=0.33115p PS=1.635u PD=1.635u
M$188 \$278 \$483 \$447 VSS sg13_lv_nmos L=0.13u W=0.74u AS=0.33115p AD=0.2516p
+ PS=1.635u PD=2.16u
M$189 \$443 \$497 \$498 VSS sg13_lv_nmos L=0.13u W=0.74u AS=0.2516p AD=0.33115p
+ PS=2.16u PD=1.635u
M$190 \$498 Veval VSS VSS sg13_lv_nmos L=0.13u W=0.74u AS=0.33115p AD=0.2516p
+ PS=1.635u PD=2.16u
M$191 \$447 \$496 VSS VSS sg13_lv_nmos L=0.13u W=0.74u AS=0.2516p AD=0.2516p
+ PS=2.16u PD=2.16u
M$192 VSS \$448 \$499 VSS sg13_lv_nmos L=0.13u W=0.74u AS=0.2516p AD=0.33115p
+ PS=2.16u PD=1.635u
M$193 \$499 \$483 \$281 VSS sg13_lv_nmos L=0.13u W=0.74u AS=0.33115p
+ AD=0.33115p PS=1.635u PD=1.635u
M$194 \$281 \$499 \$500 VSS sg13_lv_nmos L=0.13u W=0.74u AS=0.33115p
+ AD=0.33115p PS=1.635u PD=1.635u
M$195 \$500 \$448 \$283 VSS sg13_lv_nmos L=0.13u W=0.74u AS=0.33115p
+ AD=0.33115p PS=1.635u PD=1.635u
M$196 \$283 \$483 \$448 VSS sg13_lv_nmos L=0.13u W=0.74u AS=0.33115p AD=0.2516p
+ PS=1.635u PD=2.16u
M$197 \$443 \$500 \$501 VSS sg13_lv_nmos L=0.13u W=0.74u AS=0.2516p AD=0.33115p
+ PS=2.16u PD=1.635u
M$198 \$501 Veval VSS VSS sg13_lv_nmos L=0.13u W=0.74u AS=0.33115p AD=0.2516p
+ PS=1.635u PD=2.16u
M$199 \$448 \$499 VSS VSS sg13_lv_nmos L=0.13u W=0.74u AS=0.2516p AD=0.2516p
+ PS=2.16u PD=2.16u
M$200 VSS \$449 \$502 VSS sg13_lv_nmos L=0.13u W=0.74u AS=0.2516p AD=0.33115p
+ PS=2.16u PD=1.635u
M$201 \$502 \$483 \$286 VSS sg13_lv_nmos L=0.13u W=0.74u AS=0.33115p
+ AD=0.33115p PS=1.635u PD=1.635u
M$202 \$286 \$502 \$503 VSS sg13_lv_nmos L=0.13u W=0.74u AS=0.33115p
+ AD=0.33115p PS=1.635u PD=1.635u
M$203 \$503 \$449 \$288 VSS sg13_lv_nmos L=0.13u W=0.74u AS=0.33115p
+ AD=0.33115p PS=1.635u PD=1.635u
M$204 \$288 \$483 \$449 VSS sg13_lv_nmos L=0.13u W=0.74u AS=0.33115p AD=0.2516p
+ PS=1.635u PD=2.16u
M$205 \$443 \$503 \$504 VSS sg13_lv_nmos L=0.13u W=0.74u AS=0.2516p AD=0.33115p
+ PS=2.16u PD=1.635u
M$206 \$504 Veval VSS VSS sg13_lv_nmos L=0.13u W=0.74u AS=0.33115p AD=0.2516p
+ PS=1.635u PD=2.16u
M$207 \$449 \$502 VSS VSS sg13_lv_nmos L=0.13u W=0.74u AS=0.2516p AD=0.2516p
+ PS=2.16u PD=2.16u
M$208 VSS \$450 \$505 VSS sg13_lv_nmos L=0.13u W=0.74u AS=0.2516p AD=0.33115p
+ PS=2.16u PD=1.635u
M$209 \$505 \$483 \$291 VSS sg13_lv_nmos L=0.13u W=0.74u AS=0.33115p
+ AD=0.33115p PS=1.635u PD=1.635u
M$210 \$291 \$505 \$506 VSS sg13_lv_nmos L=0.13u W=0.74u AS=0.33115p
+ AD=0.33115p PS=1.635u PD=1.635u
M$211 \$506 \$450 \$293 VSS sg13_lv_nmos L=0.13u W=0.74u AS=0.33115p
+ AD=0.33115p PS=1.635u PD=1.635u
M$212 \$293 \$483 \$450 VSS sg13_lv_nmos L=0.13u W=0.74u AS=0.33115p AD=0.2516p
+ PS=1.635u PD=2.16u
M$213 \$443 \$506 \$507 VSS sg13_lv_nmos L=0.13u W=0.74u AS=0.2516p AD=0.33115p
+ PS=2.16u PD=1.635u
M$214 \$507 Veval VSS VSS sg13_lv_nmos L=0.13u W=0.74u AS=0.33115p AD=0.2516p
+ PS=1.635u PD=2.16u
M$215 \$450 \$505 VSS VSS sg13_lv_nmos L=0.13u W=0.74u AS=0.2516p AD=0.2516p
+ PS=2.16u PD=2.16u
M$216 VSS \$229 \$386 VSS sg13_lv_nmos L=0.13u W=0.74u AS=0.2516p AD=0.1406p
+ PS=2.16u PD=1.12u
M$217 \$386 \$360 \$387 VSS sg13_lv_nmos L=0.13u W=0.74u AS=0.1406p AD=0.1406p
+ PS=1.12u PD=1.12u
M$218 \$387 CLK \$388 VSS sg13_lv_nmos L=0.13u W=0.74u AS=0.1406p AD=0.1406p
+ PS=1.12u PD=1.12u
M$219 \$388 \$389 VSS VSS sg13_lv_nmos L=0.13u W=0.74u AS=0.1406p AD=0.2516p
+ PS=1.12u PD=2.16u
M$220 VSS \$387 \$389 VSS sg13_lv_nmos L=0.13u W=0.74u AS=0.2516p AD=0.1406p
+ PS=2.16u PD=1.12u
M$221 \$389 CLK \$390 VSS sg13_lv_nmos L=0.13u W=0.74u AS=0.1406p AD=0.1406p
+ PS=1.12u PD=1.12u
M$222 \$390 \$360 \$391 VSS sg13_lv_nmos L=0.13u W=0.74u AS=0.1406p AD=0.1406p
+ PS=1.12u PD=1.12u
M$223 \$391 \$392 VSS VSS sg13_lv_nmos L=0.13u W=0.74u AS=0.1406p AD=0.2516p
+ PS=1.12u PD=2.16u
M$224 VSS \$390 \$392 VSS sg13_lv_nmos L=0.13u W=0.74u AS=0.2516p AD=0.2516p
+ PS=2.16u PD=2.16u
M$225 VSS \$392 \$393 VSS sg13_lv_nmos L=0.13u W=0.74u AS=0.2516p AD=0.2516p
+ PS=2.16u PD=2.16u
M$226 VSS CLK \$360 VSS sg13_lv_nmos L=0.13u W=0.74u AS=0.2516p AD=0.2516p
+ PS=2.16u PD=2.16u
M$227 VSS \$100 \$404 VSS sg13_lv_nmos L=0.13u W=0.74u AS=0.2516p AD=0.2516p
+ PS=2.16u PD=2.16u
M$228 \$405 \$393 VSS VSS sg13_lv_nmos L=0.13u W=0.74u AS=0.2516p AD=0.1406p
+ PS=2.16u PD=1.12u
M$229 VSS \$361 \$394 VSS sg13_lv_nmos L=0.13u W=0.74u AS=0.1406p AD=0.2516p
+ PS=1.12u PD=2.16u
M$230 \$405 \$100 \$406 VSS sg13_lv_nmos L=0.13u W=0.74u AS=0.2516p AD=0.1406p
+ PS=2.16u PD=1.12u
M$231 \$406 \$404 \$394 VSS sg13_lv_nmos L=0.13u W=0.74u AS=0.1406p AD=0.2516p
+ PS=1.12u PD=2.16u
M$232 VSS \$406 \$407 VSS sg13_lv_nmos L=0.13u W=0.74u AS=0.2516p AD=0.2516p
+ PS=2.16u PD=2.16u
M$233 VSS \$407 \$395 VSS sg13_lv_nmos L=0.13u W=0.74u AS=0.2516p AD=0.1406p
+ PS=2.16u PD=1.12u
M$234 \$395 \$362 \$396 VSS sg13_lv_nmos L=0.13u W=0.74u AS=0.1406p AD=0.1406p
+ PS=1.12u PD=1.12u
M$235 \$396 CLK \$397 VSS sg13_lv_nmos L=0.13u W=0.74u AS=0.1406p AD=0.1406p
+ PS=1.12u PD=1.12u
M$236 \$397 \$398 VSS VSS sg13_lv_nmos L=0.13u W=0.74u AS=0.1406p AD=0.2516p
+ PS=1.12u PD=2.16u
M$237 VSS \$396 \$398 VSS sg13_lv_nmos L=0.13u W=0.74u AS=0.2516p AD=0.1406p
+ PS=2.16u PD=1.12u
M$238 \$398 CLK \$399 VSS sg13_lv_nmos L=0.13u W=0.74u AS=0.1406p AD=0.1406p
+ PS=1.12u PD=1.12u
M$239 \$399 \$362 \$400 VSS sg13_lv_nmos L=0.13u W=0.74u AS=0.1406p AD=0.1406p
+ PS=1.12u PD=1.12u
M$240 \$400 \$401 VSS VSS sg13_lv_nmos L=0.13u W=0.74u AS=0.1406p AD=0.2516p
+ PS=1.12u PD=2.16u
M$241 VSS \$399 \$401 VSS sg13_lv_nmos L=0.13u W=0.74u AS=0.2516p AD=0.2516p
+ PS=2.16u PD=2.16u
M$242 VSS \$401 \$141 VSS sg13_lv_nmos L=0.13u W=0.74u AS=0.2516p AD=0.2516p
+ PS=2.16u PD=2.16u
M$243 VSS CLK \$362 VSS sg13_lv_nmos L=0.13u W=0.74u AS=0.2516p AD=0.2516p
+ PS=2.16u PD=2.16u
M$244 \$483 \$573 VSS VSS sg13_lv_nmos L=0.13u W=0.74u AS=0.3663p AD=0.2516p
+ PS=2.47u PD=2.16u
M$245 VSS \$572 \$600 VSS sg13_lv_nmos L=0.13u W=0.74u AS=0.2516p AD=0.33115p
+ PS=2.16u PD=1.635u
M$246 \$600 B \$620 VSS sg13_lv_nmos L=0.13u W=0.74u AS=0.33115p AD=0.33115p
+ PS=1.635u PD=1.635u
M$247 \$620 A \$573 VSS sg13_lv_nmos L=0.13u W=0.74u AS=0.33115p AD=0.2516p
+ PS=1.635u PD=2.16u
M$248 VSS \$646 \$694 VSS sg13_lv_nmos L=0.13u W=0.74u AS=0.2516p AD=0.33115p
+ PS=2.16u PD=1.635u
M$249 \$694 \$645 \$256 VSS sg13_lv_nmos L=0.13u W=0.74u AS=0.33115p
+ AD=0.33115p PS=1.635u PD=1.635u
M$250 \$256 \$694 \$695 VSS sg13_lv_nmos L=0.13u W=0.74u AS=0.33115p
+ AD=0.33115p PS=1.635u PD=1.635u
M$251 \$695 \$646 \$258 VSS sg13_lv_nmos L=0.13u W=0.74u AS=0.33115p
+ AD=0.33115p PS=1.635u PD=1.635u
M$252 \$258 \$645 \$646 VSS sg13_lv_nmos L=0.13u W=0.74u AS=0.33115p AD=0.2516p
+ PS=1.635u PD=2.16u
M$253 \$647 \$695 \$696 VSS sg13_lv_nmos L=0.13u W=0.74u AS=0.2516p AD=0.33115p
+ PS=2.16u PD=1.635u
M$254 \$696 Veval VSS VSS sg13_lv_nmos L=0.13u W=0.74u AS=0.33115p AD=0.2516p
+ PS=1.635u PD=2.16u
M$255 \$646 \$694 VSS VSS sg13_lv_nmos L=0.13u W=0.74u AS=0.2516p AD=0.2516p
+ PS=2.16u PD=2.16u
M$256 VSS \$648 \$697 VSS sg13_lv_nmos L=0.13u W=0.74u AS=0.2516p AD=0.33115p
+ PS=2.16u PD=1.635u
M$257 \$697 \$645 \$261 VSS sg13_lv_nmos L=0.13u W=0.74u AS=0.33115p
+ AD=0.33115p PS=1.635u PD=1.635u
M$258 \$261 \$697 \$698 VSS sg13_lv_nmos L=0.13u W=0.74u AS=0.33115p
+ AD=0.33115p PS=1.635u PD=1.635u
M$259 \$698 \$648 \$263 VSS sg13_lv_nmos L=0.13u W=0.74u AS=0.33115p
+ AD=0.33115p PS=1.635u PD=1.635u
M$260 \$263 \$645 \$648 VSS sg13_lv_nmos L=0.13u W=0.74u AS=0.33115p AD=0.2516p
+ PS=1.635u PD=2.16u
M$261 \$647 \$698 \$699 VSS sg13_lv_nmos L=0.13u W=0.74u AS=0.2516p AD=0.33115p
+ PS=2.16u PD=1.635u
M$262 \$699 Veval VSS VSS sg13_lv_nmos L=0.13u W=0.74u AS=0.33115p AD=0.2516p
+ PS=1.635u PD=2.16u
M$263 \$648 \$697 VSS VSS sg13_lv_nmos L=0.13u W=0.74u AS=0.2516p AD=0.2516p
+ PS=2.16u PD=2.16u
M$264 VSS \$649 \$700 VSS sg13_lv_nmos L=0.13u W=0.74u AS=0.2516p AD=0.33115p
+ PS=2.16u PD=1.635u
M$265 \$700 \$645 \$266 VSS sg13_lv_nmos L=0.13u W=0.74u AS=0.33115p
+ AD=0.33115p PS=1.635u PD=1.635u
M$266 \$266 \$700 \$701 VSS sg13_lv_nmos L=0.13u W=0.74u AS=0.33115p
+ AD=0.33115p PS=1.635u PD=1.635u
M$267 \$701 \$649 \$268 VSS sg13_lv_nmos L=0.13u W=0.74u AS=0.33115p
+ AD=0.33115p PS=1.635u PD=1.635u
M$268 \$268 \$645 \$649 VSS sg13_lv_nmos L=0.13u W=0.74u AS=0.33115p AD=0.2516p
+ PS=1.635u PD=2.16u
M$269 \$647 \$701 \$702 VSS sg13_lv_nmos L=0.13u W=0.74u AS=0.2516p AD=0.33115p
+ PS=2.16u PD=1.635u
M$270 \$702 Veval VSS VSS sg13_lv_nmos L=0.13u W=0.74u AS=0.33115p AD=0.2516p
+ PS=1.635u PD=2.16u
M$271 \$649 \$700 VSS VSS sg13_lv_nmos L=0.13u W=0.74u AS=0.2516p AD=0.2516p
+ PS=2.16u PD=2.16u
M$272 VSS \$650 \$703 VSS sg13_lv_nmos L=0.13u W=0.74u AS=0.2516p AD=0.33115p
+ PS=2.16u PD=1.635u
M$273 \$703 \$645 \$271 VSS sg13_lv_nmos L=0.13u W=0.74u AS=0.33115p
+ AD=0.33115p PS=1.635u PD=1.635u
M$274 \$271 \$703 \$704 VSS sg13_lv_nmos L=0.13u W=0.74u AS=0.33115p
+ AD=0.33115p PS=1.635u PD=1.635u
M$275 \$704 \$650 \$273 VSS sg13_lv_nmos L=0.13u W=0.74u AS=0.33115p
+ AD=0.33115p PS=1.635u PD=1.635u
M$276 \$273 \$645 \$650 VSS sg13_lv_nmos L=0.13u W=0.74u AS=0.33115p AD=0.2516p
+ PS=1.635u PD=2.16u
M$277 \$647 \$704 \$705 VSS sg13_lv_nmos L=0.13u W=0.74u AS=0.2516p AD=0.33115p
+ PS=2.16u PD=1.635u
M$278 \$705 Veval VSS VSS sg13_lv_nmos L=0.13u W=0.74u AS=0.33115p AD=0.2516p
+ PS=1.635u PD=2.16u
M$279 \$650 \$703 VSS VSS sg13_lv_nmos L=0.13u W=0.74u AS=0.2516p AD=0.2516p
+ PS=2.16u PD=2.16u
M$280 VSS \$651 \$706 VSS sg13_lv_nmos L=0.13u W=0.74u AS=0.2516p AD=0.33115p
+ PS=2.16u PD=1.635u
M$281 \$706 \$645 \$276 VSS sg13_lv_nmos L=0.13u W=0.74u AS=0.33115p
+ AD=0.33115p PS=1.635u PD=1.635u
M$282 \$276 \$706 \$707 VSS sg13_lv_nmos L=0.13u W=0.74u AS=0.33115p
+ AD=0.33115p PS=1.635u PD=1.635u
M$283 \$707 \$651 \$278 VSS sg13_lv_nmos L=0.13u W=0.74u AS=0.33115p
+ AD=0.33115p PS=1.635u PD=1.635u
M$284 \$278 \$645 \$651 VSS sg13_lv_nmos L=0.13u W=0.74u AS=0.33115p AD=0.2516p
+ PS=1.635u PD=2.16u
M$285 \$647 \$707 \$708 VSS sg13_lv_nmos L=0.13u W=0.74u AS=0.2516p AD=0.33115p
+ PS=2.16u PD=1.635u
M$286 \$708 Veval VSS VSS sg13_lv_nmos L=0.13u W=0.74u AS=0.33115p AD=0.2516p
+ PS=1.635u PD=2.16u
M$287 \$651 \$706 VSS VSS sg13_lv_nmos L=0.13u W=0.74u AS=0.2516p AD=0.2516p
+ PS=2.16u PD=2.16u
M$288 VSS \$652 \$709 VSS sg13_lv_nmos L=0.13u W=0.74u AS=0.2516p AD=0.33115p
+ PS=2.16u PD=1.635u
M$289 \$709 \$645 \$281 VSS sg13_lv_nmos L=0.13u W=0.74u AS=0.33115p
+ AD=0.33115p PS=1.635u PD=1.635u
M$290 \$281 \$709 \$710 VSS sg13_lv_nmos L=0.13u W=0.74u AS=0.33115p
+ AD=0.33115p PS=1.635u PD=1.635u
M$291 \$710 \$652 \$283 VSS sg13_lv_nmos L=0.13u W=0.74u AS=0.33115p
+ AD=0.33115p PS=1.635u PD=1.635u
M$292 \$283 \$645 \$652 VSS sg13_lv_nmos L=0.13u W=0.74u AS=0.33115p AD=0.2516p
+ PS=1.635u PD=2.16u
M$293 \$647 \$710 \$711 VSS sg13_lv_nmos L=0.13u W=0.74u AS=0.2516p AD=0.33115p
+ PS=2.16u PD=1.635u
M$294 \$711 Veval VSS VSS sg13_lv_nmos L=0.13u W=0.74u AS=0.33115p AD=0.2516p
+ PS=1.635u PD=2.16u
M$295 \$652 \$709 VSS VSS sg13_lv_nmos L=0.13u W=0.74u AS=0.2516p AD=0.2516p
+ PS=2.16u PD=2.16u
M$296 VSS \$653 \$712 VSS sg13_lv_nmos L=0.13u W=0.74u AS=0.2516p AD=0.33115p
+ PS=2.16u PD=1.635u
M$297 \$712 \$645 \$286 VSS sg13_lv_nmos L=0.13u W=0.74u AS=0.33115p
+ AD=0.33115p PS=1.635u PD=1.635u
M$298 \$286 \$712 \$713 VSS sg13_lv_nmos L=0.13u W=0.74u AS=0.33115p
+ AD=0.33115p PS=1.635u PD=1.635u
M$299 \$713 \$653 \$288 VSS sg13_lv_nmos L=0.13u W=0.74u AS=0.33115p
+ AD=0.33115p PS=1.635u PD=1.635u
M$300 \$288 \$645 \$653 VSS sg13_lv_nmos L=0.13u W=0.74u AS=0.33115p AD=0.2516p
+ PS=1.635u PD=2.16u
M$301 \$647 \$713 \$714 VSS sg13_lv_nmos L=0.13u W=0.74u AS=0.2516p AD=0.33115p
+ PS=2.16u PD=1.635u
M$302 \$714 Veval VSS VSS sg13_lv_nmos L=0.13u W=0.74u AS=0.33115p AD=0.2516p
+ PS=1.635u PD=2.16u
M$303 \$653 \$712 VSS VSS sg13_lv_nmos L=0.13u W=0.74u AS=0.2516p AD=0.2516p
+ PS=2.16u PD=2.16u
M$304 VSS \$654 \$715 VSS sg13_lv_nmos L=0.13u W=0.74u AS=0.2516p AD=0.33115p
+ PS=2.16u PD=1.635u
M$305 \$715 \$645 \$291 VSS sg13_lv_nmos L=0.13u W=0.74u AS=0.33115p
+ AD=0.33115p PS=1.635u PD=1.635u
M$306 \$291 \$715 \$716 VSS sg13_lv_nmos L=0.13u W=0.74u AS=0.33115p
+ AD=0.33115p PS=1.635u PD=1.635u
M$307 \$716 \$654 \$293 VSS sg13_lv_nmos L=0.13u W=0.74u AS=0.33115p
+ AD=0.33115p PS=1.635u PD=1.635u
M$308 \$293 \$645 \$654 VSS sg13_lv_nmos L=0.13u W=0.74u AS=0.33115p AD=0.2516p
+ PS=1.635u PD=2.16u
M$309 \$647 \$716 \$717 VSS sg13_lv_nmos L=0.13u W=0.74u AS=0.2516p AD=0.33115p
+ PS=2.16u PD=1.635u
M$310 \$717 Veval VSS VSS sg13_lv_nmos L=0.13u W=0.74u AS=0.33115p AD=0.2516p
+ PS=1.635u PD=2.16u
M$311 \$654 \$715 VSS VSS sg13_lv_nmos L=0.13u W=0.74u AS=0.2516p AD=0.2516p
+ PS=2.16u PD=2.16u
M$312 VSS Veval \$601 VSS sg13_lv_nmos L=0.13u W=0.74u AS=0.2516p AD=0.2516p
+ PS=2.16u PD=2.16u
M$313 VSS \$601 \$574 VSS sg13_lv_nmos L=0.13u W=2.96u AS=1.0064p AD=1.0064p
+ PS=6.6u PD=6.6u
M$314 VSS \$574 \$575 VSS sg13_lv_nmos L=0.13u W=0.74u AS=0.2516p AD=0.2516p
+ PS=2.16u PD=2.16u
M$315 VSS \$575 \$576 VSS sg13_lv_nmos L=0.13u W=2.96u AS=1.0064p AD=1.0064p
+ PS=6.6u PD=6.6u
M$316 \$845 \$575 \$602 VSS sg13_lv_nmos L=0.13u W=0.74u AS=0.2516p AD=0.2516p
+ PS=2.16u PD=2.16u
M$317 VSS \$602 \$603 VSS sg13_lv_nmos L=0.13u W=0.74u AS=0.2516p AD=0.2516p
+ PS=2.16u PD=2.16u
M$318 VSS \$603 \$604 VSS sg13_lv_nmos L=0.13u W=0.74u AS=0.2516p AD=0.2516p
+ PS=2.16u PD=2.16u
M$319 \$602 \$576 \$605 VSS sg13_lv_nmos L=0.13u W=0.74u AS=0.2516p AD=0.2516p
+ PS=2.16u PD=2.16u
M$320 \$605 \$603 VSS VSS sg13_lv_nmos L=0.13u W=0.74u AS=0.2516p AD=0.2516p
+ PS=2.16u PD=2.16u
M$321 VSS \$604 \$630 VSS sg13_lv_nmos L=0.13u W=0.74u AS=0.2516p AD=0.1406p
+ PS=2.16u PD=1.12u
M$322 \$630 \$606 \$631 VSS sg13_lv_nmos L=0.13u W=0.74u AS=0.1406p AD=0.1406p
+ PS=1.12u PD=1.12u
M$323 \$631 CLK \$632 VSS sg13_lv_nmos L=0.13u W=0.74u AS=0.1406p AD=0.1406p
+ PS=1.12u PD=1.12u
M$324 \$632 \$633 VSS VSS sg13_lv_nmos L=0.13u W=0.74u AS=0.1406p AD=0.2516p
+ PS=1.12u PD=2.16u
M$325 VSS \$631 \$633 VSS sg13_lv_nmos L=0.13u W=0.74u AS=0.2516p AD=0.1406p
+ PS=2.16u PD=1.12u
M$326 \$633 CLK \$634 VSS sg13_lv_nmos L=0.13u W=0.74u AS=0.1406p AD=0.1406p
+ PS=1.12u PD=1.12u
M$327 \$634 \$606 \$635 VSS sg13_lv_nmos L=0.13u W=0.74u AS=0.1406p AD=0.1406p
+ PS=1.12u PD=1.12u
M$328 \$635 \$636 VSS VSS sg13_lv_nmos L=0.13u W=0.74u AS=0.1406p AD=0.2516p
+ PS=1.12u PD=2.16u
M$329 VSS \$634 \$636 VSS sg13_lv_nmos L=0.13u W=0.74u AS=0.2516p AD=0.2516p
+ PS=2.16u PD=2.16u
M$330 VSS \$636 \$637 VSS sg13_lv_nmos L=0.13u W=0.74u AS=0.2516p AD=0.2516p
+ PS=2.16u PD=2.16u
M$331 VSS CLK \$606 VSS sg13_lv_nmos L=0.13u W=0.74u AS=0.2516p AD=0.2516p
+ PS=2.16u PD=2.16u
M$332 VSS \$100 \$655 VSS sg13_lv_nmos L=0.13u W=0.74u AS=0.2516p AD=0.2516p
+ PS=2.16u PD=2.16u
M$333 \$656 \$637 VSS VSS sg13_lv_nmos L=0.13u W=0.74u AS=0.2516p AD=0.1406p
+ PS=2.16u PD=1.12u
M$334 VSS \$607 \$621 VSS sg13_lv_nmos L=0.13u W=0.74u AS=0.1406p AD=0.2516p
+ PS=1.12u PD=2.16u
M$335 \$656 \$100 \$657 VSS sg13_lv_nmos L=0.13u W=0.74u AS=0.2516p AD=0.1406p
+ PS=2.16u PD=1.12u
M$336 \$657 \$655 \$621 VSS sg13_lv_nmos L=0.13u W=0.74u AS=0.1406p AD=0.2516p
+ PS=1.12u PD=2.16u
M$337 VSS \$657 \$658 VSS sg13_lv_nmos L=0.13u W=0.74u AS=0.2516p AD=0.2516p
+ PS=2.16u PD=2.16u
M$338 VSS \$658 \$638 VSS sg13_lv_nmos L=0.13u W=0.74u AS=0.2516p AD=0.1406p
+ PS=2.16u PD=1.12u
M$339 \$638 \$608 \$639 VSS sg13_lv_nmos L=0.13u W=0.74u AS=0.1406p AD=0.1406p
+ PS=1.12u PD=1.12u
M$340 \$639 CLK \$640 VSS sg13_lv_nmos L=0.13u W=0.74u AS=0.1406p AD=0.1406p
+ PS=1.12u PD=1.12u
M$341 \$640 \$641 VSS VSS sg13_lv_nmos L=0.13u W=0.74u AS=0.1406p AD=0.2516p
+ PS=1.12u PD=2.16u
M$342 VSS \$639 \$641 VSS sg13_lv_nmos L=0.13u W=0.74u AS=0.2516p AD=0.1406p
+ PS=2.16u PD=1.12u
M$343 \$641 CLK \$642 VSS sg13_lv_nmos L=0.13u W=0.74u AS=0.1406p AD=0.1406p
+ PS=1.12u PD=1.12u
M$344 \$642 \$608 \$643 VSS sg13_lv_nmos L=0.13u W=0.74u AS=0.1406p AD=0.1406p
+ PS=1.12u PD=1.12u
M$345 \$643 \$644 VSS VSS sg13_lv_nmos L=0.13u W=0.74u AS=0.1406p AD=0.2516p
+ PS=1.12u PD=2.16u
M$346 VSS \$642 \$644 VSS sg13_lv_nmos L=0.13u W=0.74u AS=0.2516p AD=0.2516p
+ PS=2.16u PD=2.16u
M$347 VSS \$644 \$361 VSS sg13_lv_nmos L=0.13u W=0.74u AS=0.2516p AD=0.2516p
+ PS=2.16u PD=2.16u
M$348 VSS CLK \$608 VSS sg13_lv_nmos L=0.13u W=0.74u AS=0.2516p AD=0.2516p
+ PS=2.16u PD=2.16u
M$349 \$843 \$856 VSS VSS sg13_lv_nmos L=0.13u W=0.74u AS=0.3663p AD=0.2516p
+ PS=2.47u PD=2.16u
M$350 \$645 \$788 VSS VSS sg13_lv_nmos L=0.13u W=0.74u AS=0.3663p AD=0.2516p
+ PS=2.47u PD=2.16u
M$351 VSS C \$787 VSS sg13_lv_nmos L=0.13u W=0.74u AS=0.2516p AD=0.33115p
+ PS=2.16u PD=1.635u
M$352 \$787 \$786 \$838 VSS sg13_lv_nmos L=0.13u W=0.74u AS=0.33115p
+ AD=0.33115p PS=1.635u PD=1.635u
M$353 \$838 A \$788 VSS sg13_lv_nmos L=0.13u W=0.74u AS=0.33115p AD=0.2516p
+ PS=1.635u PD=2.16u
M$354 VSS \$844 \$863 VSS sg13_lv_nmos L=0.13u W=0.74u AS=0.2516p AD=0.33115p
+ PS=2.16u PD=1.635u
M$355 \$863 \$843 \$256 VSS sg13_lv_nmos L=0.13u W=0.74u AS=0.33115p
+ AD=0.33115p PS=1.635u PD=1.635u
M$356 \$256 \$863 \$864 VSS sg13_lv_nmos L=0.13u W=0.74u AS=0.33115p
+ AD=0.33115p PS=1.635u PD=1.635u
M$357 \$864 \$844 \$258 VSS sg13_lv_nmos L=0.13u W=0.74u AS=0.33115p
+ AD=0.33115p PS=1.635u PD=1.635u
M$358 \$258 \$843 \$844 VSS sg13_lv_nmos L=0.13u W=0.74u AS=0.33115p AD=0.2516p
+ PS=1.635u PD=2.16u
M$359 \$845 \$864 \$865 VSS sg13_lv_nmos L=0.13u W=0.74u AS=0.2516p AD=0.33115p
+ PS=2.16u PD=1.635u
M$360 \$865 Veval VSS VSS sg13_lv_nmos L=0.13u W=0.74u AS=0.33115p AD=0.2516p
+ PS=1.635u PD=2.16u
M$361 \$844 \$863 VSS VSS sg13_lv_nmos L=0.13u W=0.74u AS=0.2516p AD=0.2516p
+ PS=2.16u PD=2.16u
M$362 VSS \$846 \$866 VSS sg13_lv_nmos L=0.13u W=0.74u AS=0.2516p AD=0.33115p
+ PS=2.16u PD=1.635u
M$363 \$866 \$843 \$261 VSS sg13_lv_nmos L=0.13u W=0.74u AS=0.33115p
+ AD=0.33115p PS=1.635u PD=1.635u
M$364 \$261 \$866 \$867 VSS sg13_lv_nmos L=0.13u W=0.74u AS=0.33115p
+ AD=0.33115p PS=1.635u PD=1.635u
M$365 \$867 \$846 \$263 VSS sg13_lv_nmos L=0.13u W=0.74u AS=0.33115p
+ AD=0.33115p PS=1.635u PD=1.635u
M$366 \$263 \$843 \$846 VSS sg13_lv_nmos L=0.13u W=0.74u AS=0.33115p AD=0.2516p
+ PS=1.635u PD=2.16u
M$367 \$845 \$867 \$868 VSS sg13_lv_nmos L=0.13u W=0.74u AS=0.2516p AD=0.33115p
+ PS=2.16u PD=1.635u
M$368 \$868 Veval VSS VSS sg13_lv_nmos L=0.13u W=0.74u AS=0.33115p AD=0.2516p
+ PS=1.635u PD=2.16u
M$369 \$846 \$866 VSS VSS sg13_lv_nmos L=0.13u W=0.74u AS=0.2516p AD=0.2516p
+ PS=2.16u PD=2.16u
M$370 VSS \$847 \$869 VSS sg13_lv_nmos L=0.13u W=0.74u AS=0.2516p AD=0.33115p
+ PS=2.16u PD=1.635u
M$371 \$869 \$843 \$266 VSS sg13_lv_nmos L=0.13u W=0.74u AS=0.33115p
+ AD=0.33115p PS=1.635u PD=1.635u
M$372 \$266 \$869 \$870 VSS sg13_lv_nmos L=0.13u W=0.74u AS=0.33115p
+ AD=0.33115p PS=1.635u PD=1.635u
M$373 \$870 \$847 \$268 VSS sg13_lv_nmos L=0.13u W=0.74u AS=0.33115p
+ AD=0.33115p PS=1.635u PD=1.635u
M$374 \$268 \$843 \$847 VSS sg13_lv_nmos L=0.13u W=0.74u AS=0.33115p AD=0.2516p
+ PS=1.635u PD=2.16u
M$375 \$845 \$870 \$871 VSS sg13_lv_nmos L=0.13u W=0.74u AS=0.2516p AD=0.33115p
+ PS=2.16u PD=1.635u
M$376 \$871 Veval VSS VSS sg13_lv_nmos L=0.13u W=0.74u AS=0.33115p AD=0.2516p
+ PS=1.635u PD=2.16u
M$377 \$847 \$869 VSS VSS sg13_lv_nmos L=0.13u W=0.74u AS=0.2516p AD=0.2516p
+ PS=2.16u PD=2.16u
M$378 VSS \$848 \$872 VSS sg13_lv_nmos L=0.13u W=0.74u AS=0.2516p AD=0.33115p
+ PS=2.16u PD=1.635u
M$379 \$872 \$843 \$271 VSS sg13_lv_nmos L=0.13u W=0.74u AS=0.33115p
+ AD=0.33115p PS=1.635u PD=1.635u
M$380 \$271 \$872 \$873 VSS sg13_lv_nmos L=0.13u W=0.74u AS=0.33115p
+ AD=0.33115p PS=1.635u PD=1.635u
M$381 \$873 \$848 \$273 VSS sg13_lv_nmos L=0.13u W=0.74u AS=0.33115p
+ AD=0.33115p PS=1.635u PD=1.635u
M$382 \$273 \$843 \$848 VSS sg13_lv_nmos L=0.13u W=0.74u AS=0.33115p AD=0.2516p
+ PS=1.635u PD=2.16u
M$383 \$845 \$873 \$874 VSS sg13_lv_nmos L=0.13u W=0.74u AS=0.2516p AD=0.33115p
+ PS=2.16u PD=1.635u
M$384 \$874 Veval VSS VSS sg13_lv_nmos L=0.13u W=0.74u AS=0.33115p AD=0.2516p
+ PS=1.635u PD=2.16u
M$385 \$848 \$872 VSS VSS sg13_lv_nmos L=0.13u W=0.74u AS=0.2516p AD=0.2516p
+ PS=2.16u PD=2.16u
M$386 VSS \$849 \$875 VSS sg13_lv_nmos L=0.13u W=0.74u AS=0.2516p AD=0.33115p
+ PS=2.16u PD=1.635u
M$387 \$875 \$843 \$276 VSS sg13_lv_nmos L=0.13u W=0.74u AS=0.33115p
+ AD=0.33115p PS=1.635u PD=1.635u
M$388 \$276 \$875 \$876 VSS sg13_lv_nmos L=0.13u W=0.74u AS=0.33115p
+ AD=0.33115p PS=1.635u PD=1.635u
M$389 \$876 \$849 \$278 VSS sg13_lv_nmos L=0.13u W=0.74u AS=0.33115p
+ AD=0.33115p PS=1.635u PD=1.635u
M$390 \$278 \$843 \$849 VSS sg13_lv_nmos L=0.13u W=0.74u AS=0.33115p AD=0.2516p
+ PS=1.635u PD=2.16u
M$391 \$845 \$876 \$877 VSS sg13_lv_nmos L=0.13u W=0.74u AS=0.2516p AD=0.33115p
+ PS=2.16u PD=1.635u
M$392 \$877 Veval VSS VSS sg13_lv_nmos L=0.13u W=0.74u AS=0.33115p AD=0.2516p
+ PS=1.635u PD=2.16u
M$393 \$849 \$875 VSS VSS sg13_lv_nmos L=0.13u W=0.74u AS=0.2516p AD=0.2516p
+ PS=2.16u PD=2.16u
M$394 VSS \$850 \$878 VSS sg13_lv_nmos L=0.13u W=0.74u AS=0.2516p AD=0.33115p
+ PS=2.16u PD=1.635u
M$395 \$878 \$843 \$281 VSS sg13_lv_nmos L=0.13u W=0.74u AS=0.33115p
+ AD=0.33115p PS=1.635u PD=1.635u
M$396 \$281 \$878 \$879 VSS sg13_lv_nmos L=0.13u W=0.74u AS=0.33115p
+ AD=0.33115p PS=1.635u PD=1.635u
M$397 \$879 \$850 \$283 VSS sg13_lv_nmos L=0.13u W=0.74u AS=0.33115p
+ AD=0.33115p PS=1.635u PD=1.635u
M$398 \$283 \$843 \$850 VSS sg13_lv_nmos L=0.13u W=0.74u AS=0.33115p AD=0.2516p
+ PS=1.635u PD=2.16u
M$399 \$845 \$879 \$880 VSS sg13_lv_nmos L=0.13u W=0.74u AS=0.2516p AD=0.33115p
+ PS=2.16u PD=1.635u
M$400 \$880 Veval VSS VSS sg13_lv_nmos L=0.13u W=0.74u AS=0.33115p AD=0.2516p
+ PS=1.635u PD=2.16u
M$401 \$850 \$878 VSS VSS sg13_lv_nmos L=0.13u W=0.74u AS=0.2516p AD=0.2516p
+ PS=2.16u PD=2.16u
M$402 VSS \$851 \$881 VSS sg13_lv_nmos L=0.13u W=0.74u AS=0.2516p AD=0.33115p
+ PS=2.16u PD=1.635u
M$403 \$881 \$843 \$286 VSS sg13_lv_nmos L=0.13u W=0.74u AS=0.33115p
+ AD=0.33115p PS=1.635u PD=1.635u
M$404 \$286 \$881 \$882 VSS sg13_lv_nmos L=0.13u W=0.74u AS=0.33115p
+ AD=0.33115p PS=1.635u PD=1.635u
M$405 \$882 \$851 \$288 VSS sg13_lv_nmos L=0.13u W=0.74u AS=0.33115p
+ AD=0.33115p PS=1.635u PD=1.635u
M$406 \$288 \$843 \$851 VSS sg13_lv_nmos L=0.13u W=0.74u AS=0.33115p AD=0.2516p
+ PS=1.635u PD=2.16u
M$407 \$845 \$882 \$883 VSS sg13_lv_nmos L=0.13u W=0.74u AS=0.2516p AD=0.33115p
+ PS=2.16u PD=1.635u
M$408 \$883 Veval VSS VSS sg13_lv_nmos L=0.13u W=0.74u AS=0.33115p AD=0.2516p
+ PS=1.635u PD=2.16u
M$409 \$851 \$881 VSS VSS sg13_lv_nmos L=0.13u W=0.74u AS=0.2516p AD=0.2516p
+ PS=2.16u PD=2.16u
M$410 VSS \$852 \$884 VSS sg13_lv_nmos L=0.13u W=0.74u AS=0.2516p AD=0.33115p
+ PS=2.16u PD=1.635u
M$411 \$884 \$843 \$291 VSS sg13_lv_nmos L=0.13u W=0.74u AS=0.33115p
+ AD=0.33115p PS=1.635u PD=1.635u
M$412 \$291 \$884 \$885 VSS sg13_lv_nmos L=0.13u W=0.74u AS=0.33115p
+ AD=0.33115p PS=1.635u PD=1.635u
M$413 \$885 \$852 \$293 VSS sg13_lv_nmos L=0.13u W=0.74u AS=0.33115p
+ AD=0.33115p PS=1.635u PD=1.635u
M$414 \$293 \$843 \$852 VSS sg13_lv_nmos L=0.13u W=0.74u AS=0.33115p AD=0.2516p
+ PS=1.635u PD=2.16u
M$415 \$845 \$885 \$886 VSS sg13_lv_nmos L=0.13u W=0.74u AS=0.2516p AD=0.33115p
+ PS=2.16u PD=1.635u
M$416 \$886 Veval VSS VSS sg13_lv_nmos L=0.13u W=0.74u AS=0.33115p AD=0.2516p
+ PS=1.635u PD=2.16u
M$417 \$852 \$884 VSS VSS sg13_lv_nmos L=0.13u W=0.74u AS=0.2516p AD=0.2516p
+ PS=2.16u PD=2.16u
M$418 VSS \$1007 \$857 VSS sg13_lv_nmos L=0.13u W=2.96u AS=1.0064p AD=1.0064p
+ PS=6.6u PD=6.6u
M$419 VSS \$967 \$858 VSS sg13_lv_nmos L=0.13u W=2.96u AS=1.0064p AD=1.0064p
+ PS=6.6u PD=6.6u
M$420 \$1075 \$1096 VSS VSS sg13_lv_nmos L=0.13u W=0.74u AS=0.3663p AD=0.2516p
+ PS=2.47u PD=2.16u
M$421 VSS \$572 \$1006 VSS sg13_lv_nmos L=0.13u W=0.74u AS=0.2516p AD=0.33115p
+ PS=2.16u PD=1.635u
M$422 \$1006 \$786 \$1036 VSS sg13_lv_nmos L=0.13u W=0.74u AS=0.33115p
+ AD=0.33115p PS=1.635u PD=1.635u
M$423 \$1036 A \$856 VSS sg13_lv_nmos L=0.13u W=0.74u AS=0.33115p AD=0.2516p
+ PS=1.635u PD=2.16u
M$424 VSS \$1084 \$1097 VSS sg13_lv_nmos L=0.13u W=0.74u AS=0.2516p AD=0.33115p
+ PS=2.16u PD=1.635u
M$425 \$1097 \$1075 \$256 VSS sg13_lv_nmos L=0.13u W=0.74u AS=0.33115p
+ AD=0.33115p PS=1.635u PD=1.635u
M$426 \$256 \$1097 \$1098 VSS sg13_lv_nmos L=0.13u W=0.74u AS=0.33115p
+ AD=0.33115p PS=1.635u PD=1.635u
M$427 \$1098 \$1084 \$258 VSS sg13_lv_nmos L=0.13u W=0.74u AS=0.33115p
+ AD=0.33115p PS=1.635u PD=1.635u
M$428 \$258 \$1075 \$1084 VSS sg13_lv_nmos L=0.13u W=0.74u AS=0.33115p
+ AD=0.2516p PS=1.635u PD=2.16u
M$429 \$1083 \$1098 \$1099 VSS sg13_lv_nmos L=0.13u W=0.74u AS=0.2516p
+ AD=0.33115p PS=2.16u PD=1.635u
M$430 \$1099 Veval VSS VSS sg13_lv_nmos L=0.13u W=0.74u AS=0.33115p AD=0.2516p
+ PS=1.635u PD=2.16u
M$431 \$1084 \$1097 VSS VSS sg13_lv_nmos L=0.13u W=0.74u AS=0.2516p AD=0.2516p
+ PS=2.16u PD=2.16u
M$432 VSS \$1085 \$1100 VSS sg13_lv_nmos L=0.13u W=0.74u AS=0.2516p AD=0.33115p
+ PS=2.16u PD=1.635u
M$433 \$1100 \$1075 \$261 VSS sg13_lv_nmos L=0.13u W=0.74u AS=0.33115p
+ AD=0.33115p PS=1.635u PD=1.635u
M$434 \$261 \$1100 \$1101 VSS sg13_lv_nmos L=0.13u W=0.74u AS=0.33115p
+ AD=0.33115p PS=1.635u PD=1.635u
M$435 \$1101 \$1085 \$263 VSS sg13_lv_nmos L=0.13u W=0.74u AS=0.33115p
+ AD=0.33115p PS=1.635u PD=1.635u
M$436 \$263 \$1075 \$1085 VSS sg13_lv_nmos L=0.13u W=0.74u AS=0.33115p
+ AD=0.2516p PS=1.635u PD=2.16u
M$437 \$1083 \$1101 \$1102 VSS sg13_lv_nmos L=0.13u W=0.74u AS=0.2516p
+ AD=0.33115p PS=2.16u PD=1.635u
M$438 \$1102 Veval VSS VSS sg13_lv_nmos L=0.13u W=0.74u AS=0.33115p AD=0.2516p
+ PS=1.635u PD=2.16u
M$439 \$1085 \$1100 VSS VSS sg13_lv_nmos L=0.13u W=0.74u AS=0.2516p AD=0.2516p
+ PS=2.16u PD=2.16u
M$440 VSS \$1086 \$1103 VSS sg13_lv_nmos L=0.13u W=0.74u AS=0.2516p AD=0.33115p
+ PS=2.16u PD=1.635u
M$441 \$1103 \$1075 \$266 VSS sg13_lv_nmos L=0.13u W=0.74u AS=0.33115p
+ AD=0.33115p PS=1.635u PD=1.635u
M$442 \$266 \$1103 \$1104 VSS sg13_lv_nmos L=0.13u W=0.74u AS=0.33115p
+ AD=0.33115p PS=1.635u PD=1.635u
M$443 \$1104 \$1086 \$268 VSS sg13_lv_nmos L=0.13u W=0.74u AS=0.33115p
+ AD=0.33115p PS=1.635u PD=1.635u
M$444 \$268 \$1075 \$1086 VSS sg13_lv_nmos L=0.13u W=0.74u AS=0.33115p
+ AD=0.2516p PS=1.635u PD=2.16u
M$445 \$1083 \$1104 \$1105 VSS sg13_lv_nmos L=0.13u W=0.74u AS=0.2516p
+ AD=0.33115p PS=2.16u PD=1.635u
M$446 \$1105 Veval VSS VSS sg13_lv_nmos L=0.13u W=0.74u AS=0.33115p AD=0.2516p
+ PS=1.635u PD=2.16u
M$447 \$1086 \$1103 VSS VSS sg13_lv_nmos L=0.13u W=0.74u AS=0.2516p AD=0.2516p
+ PS=2.16u PD=2.16u
M$448 VSS \$1087 \$1106 VSS sg13_lv_nmos L=0.13u W=0.74u AS=0.2516p AD=0.33115p
+ PS=2.16u PD=1.635u
M$449 \$1106 \$1075 \$271 VSS sg13_lv_nmos L=0.13u W=0.74u AS=0.33115p
+ AD=0.33115p PS=1.635u PD=1.635u
M$450 \$271 \$1106 \$1107 VSS sg13_lv_nmos L=0.13u W=0.74u AS=0.33115p
+ AD=0.33115p PS=1.635u PD=1.635u
M$451 \$1107 \$1087 \$273 VSS sg13_lv_nmos L=0.13u W=0.74u AS=0.33115p
+ AD=0.33115p PS=1.635u PD=1.635u
M$452 \$273 \$1075 \$1087 VSS sg13_lv_nmos L=0.13u W=0.74u AS=0.33115p
+ AD=0.2516p PS=1.635u PD=2.16u
M$453 \$1083 \$1107 \$1108 VSS sg13_lv_nmos L=0.13u W=0.74u AS=0.2516p
+ AD=0.33115p PS=2.16u PD=1.635u
M$454 \$1108 Veval VSS VSS sg13_lv_nmos L=0.13u W=0.74u AS=0.33115p AD=0.2516p
+ PS=1.635u PD=2.16u
M$455 \$1087 \$1106 VSS VSS sg13_lv_nmos L=0.13u W=0.74u AS=0.2516p AD=0.2516p
+ PS=2.16u PD=2.16u
M$456 VSS \$1088 \$1109 VSS sg13_lv_nmos L=0.13u W=0.74u AS=0.2516p AD=0.33115p
+ PS=2.16u PD=1.635u
M$457 \$1109 \$1075 \$276 VSS sg13_lv_nmos L=0.13u W=0.74u AS=0.33115p
+ AD=0.33115p PS=1.635u PD=1.635u
M$458 \$276 \$1109 \$1110 VSS sg13_lv_nmos L=0.13u W=0.74u AS=0.33115p
+ AD=0.33115p PS=1.635u PD=1.635u
M$459 \$1110 \$1088 \$278 VSS sg13_lv_nmos L=0.13u W=0.74u AS=0.33115p
+ AD=0.33115p PS=1.635u PD=1.635u
M$460 \$278 \$1075 \$1088 VSS sg13_lv_nmos L=0.13u W=0.74u AS=0.33115p
+ AD=0.2516p PS=1.635u PD=2.16u
M$461 \$1083 \$1110 \$1111 VSS sg13_lv_nmos L=0.13u W=0.74u AS=0.2516p
+ AD=0.33115p PS=2.16u PD=1.635u
M$462 \$1111 Veval VSS VSS sg13_lv_nmos L=0.13u W=0.74u AS=0.33115p AD=0.2516p
+ PS=1.635u PD=2.16u
M$463 \$1088 \$1109 VSS VSS sg13_lv_nmos L=0.13u W=0.74u AS=0.2516p AD=0.2516p
+ PS=2.16u PD=2.16u
M$464 VSS \$1089 \$1112 VSS sg13_lv_nmos L=0.13u W=0.74u AS=0.2516p AD=0.33115p
+ PS=2.16u PD=1.635u
M$465 \$1112 \$1075 \$281 VSS sg13_lv_nmos L=0.13u W=0.74u AS=0.33115p
+ AD=0.33115p PS=1.635u PD=1.635u
M$466 \$281 \$1112 \$1113 VSS sg13_lv_nmos L=0.13u W=0.74u AS=0.33115p
+ AD=0.33115p PS=1.635u PD=1.635u
M$467 \$1113 \$1089 \$283 VSS sg13_lv_nmos L=0.13u W=0.74u AS=0.33115p
+ AD=0.33115p PS=1.635u PD=1.635u
M$468 \$283 \$1075 \$1089 VSS sg13_lv_nmos L=0.13u W=0.74u AS=0.33115p
+ AD=0.2516p PS=1.635u PD=2.16u
M$469 \$1083 \$1113 \$1114 VSS sg13_lv_nmos L=0.13u W=0.74u AS=0.2516p
+ AD=0.33115p PS=2.16u PD=1.635u
M$470 \$1114 Veval VSS VSS sg13_lv_nmos L=0.13u W=0.74u AS=0.33115p AD=0.2516p
+ PS=1.635u PD=2.16u
M$471 \$1089 \$1112 VSS VSS sg13_lv_nmos L=0.13u W=0.74u AS=0.2516p AD=0.2516p
+ PS=2.16u PD=2.16u
M$472 VSS \$1090 \$1115 VSS sg13_lv_nmos L=0.13u W=0.74u AS=0.2516p AD=0.33115p
+ PS=2.16u PD=1.635u
M$473 \$1115 \$1075 \$286 VSS sg13_lv_nmos L=0.13u W=0.74u AS=0.33115p
+ AD=0.33115p PS=1.635u PD=1.635u
M$474 \$286 \$1115 \$1116 VSS sg13_lv_nmos L=0.13u W=0.74u AS=0.33115p
+ AD=0.33115p PS=1.635u PD=1.635u
M$475 \$1116 \$1090 \$288 VSS sg13_lv_nmos L=0.13u W=0.74u AS=0.33115p
+ AD=0.33115p PS=1.635u PD=1.635u
M$476 \$288 \$1075 \$1090 VSS sg13_lv_nmos L=0.13u W=0.74u AS=0.33115p
+ AD=0.2516p PS=1.635u PD=2.16u
M$477 \$1083 \$1116 \$1117 VSS sg13_lv_nmos L=0.13u W=0.74u AS=0.2516p
+ AD=0.33115p PS=2.16u PD=1.635u
M$478 \$1117 Veval VSS VSS sg13_lv_nmos L=0.13u W=0.74u AS=0.33115p AD=0.2516p
+ PS=1.635u PD=2.16u
M$479 \$1090 \$1115 VSS VSS sg13_lv_nmos L=0.13u W=0.74u AS=0.2516p AD=0.2516p
+ PS=2.16u PD=2.16u
M$480 VSS \$1091 \$1118 VSS sg13_lv_nmos L=0.13u W=0.74u AS=0.2516p AD=0.33115p
+ PS=2.16u PD=1.635u
M$481 \$1118 \$1075 \$291 VSS sg13_lv_nmos L=0.13u W=0.74u AS=0.33115p
+ AD=0.33115p PS=1.635u PD=1.635u
M$482 \$291 \$1118 \$1119 VSS sg13_lv_nmos L=0.13u W=0.74u AS=0.33115p
+ AD=0.33115p PS=1.635u PD=1.635u
M$483 \$1119 \$1091 \$293 VSS sg13_lv_nmos L=0.13u W=0.74u AS=0.33115p
+ AD=0.33115p PS=1.635u PD=1.635u
M$484 \$293 \$1075 \$1091 VSS sg13_lv_nmos L=0.13u W=0.74u AS=0.33115p
+ AD=0.2516p PS=1.635u PD=2.16u
M$485 \$1083 \$1119 \$1120 VSS sg13_lv_nmos L=0.13u W=0.74u AS=0.2516p
+ AD=0.33115p PS=2.16u PD=1.635u
M$486 \$1120 Veval VSS VSS sg13_lv_nmos L=0.13u W=0.74u AS=0.33115p AD=0.2516p
+ PS=1.635u PD=2.16u
M$487 \$1091 \$1118 VSS VSS sg13_lv_nmos L=0.13u W=0.74u AS=0.2516p AD=0.2516p
+ PS=2.16u PD=2.16u
M$488 VSS Veval \$1007 VSS sg13_lv_nmos L=0.13u W=0.74u AS=0.2516p AD=0.2516p
+ PS=2.16u PD=2.16u
M$489 VSS \$857 \$967 VSS sg13_lv_nmos L=0.13u W=0.74u AS=0.2516p AD=0.2516p
+ PS=2.16u PD=2.16u
M$490 \$1083 \$967 \$1008 VSS sg13_lv_nmos L=0.13u W=0.74u AS=0.2516p
+ AD=0.2516p PS=2.16u PD=2.16u
M$491 VSS \$1008 \$1009 VSS sg13_lv_nmos L=0.13u W=0.74u AS=0.2516p AD=0.2516p
+ PS=2.16u PD=2.16u
M$492 VSS \$1009 \$1010 VSS sg13_lv_nmos L=0.13u W=0.74u AS=0.2516p AD=0.2516p
+ PS=2.16u PD=2.16u
M$493 \$1008 \$858 \$1011 VSS sg13_lv_nmos L=0.13u W=0.74u AS=0.2516p
+ AD=0.2516p PS=2.16u PD=2.16u
M$494 \$1011 \$1009 VSS VSS sg13_lv_nmos L=0.13u W=0.74u AS=0.2516p AD=0.2516p
+ PS=2.16u PD=2.16u
M$495 VSS \$1010 \$887 VSS sg13_lv_nmos L=0.13u W=0.74u AS=0.2516p AD=0.1406p
+ PS=2.16u PD=1.12u
M$496 \$887 \$853 \$888 VSS sg13_lv_nmos L=0.13u W=0.74u AS=0.1406p AD=0.1406p
+ PS=1.12u PD=1.12u
M$497 \$888 CLK \$889 VSS sg13_lv_nmos L=0.13u W=0.74u AS=0.1406p AD=0.1406p
+ PS=1.12u PD=1.12u
M$498 \$889 \$890 VSS VSS sg13_lv_nmos L=0.13u W=0.74u AS=0.1406p AD=0.2516p
+ PS=1.12u PD=2.16u
M$499 VSS \$888 \$890 VSS sg13_lv_nmos L=0.13u W=0.74u AS=0.2516p AD=0.1406p
+ PS=2.16u PD=1.12u
M$500 \$890 CLK \$891 VSS sg13_lv_nmos L=0.13u W=0.74u AS=0.1406p AD=0.1406p
+ PS=1.12u PD=1.12u
M$501 \$891 \$853 \$892 VSS sg13_lv_nmos L=0.13u W=0.74u AS=0.1406p AD=0.1406p
+ PS=1.12u PD=1.12u
M$502 \$892 \$893 VSS VSS sg13_lv_nmos L=0.13u W=0.74u AS=0.1406p AD=0.2516p
+ PS=1.12u PD=2.16u
M$503 VSS \$891 \$893 VSS sg13_lv_nmos L=0.13u W=0.74u AS=0.2516p AD=0.2516p
+ PS=2.16u PD=2.16u
M$504 VSS \$893 \$894 VSS sg13_lv_nmos L=0.13u W=0.74u AS=0.2516p AD=0.2516p
+ PS=2.16u PD=2.16u
M$505 VSS CLK \$853 VSS sg13_lv_nmos L=0.13u W=0.74u AS=0.2516p AD=0.2516p
+ PS=2.16u PD=2.16u
M$506 VSS \$100 \$968 VSS sg13_lv_nmos L=0.13u W=0.74u AS=0.2516p AD=0.2516p
+ PS=2.16u PD=2.16u
M$507 \$969 \$894 VSS VSS sg13_lv_nmos L=0.13u W=0.74u AS=0.2516p AD=0.1406p
+ PS=2.16u PD=1.12u
M$508 VSS \$854 \$895 VSS sg13_lv_nmos L=0.13u W=0.74u AS=0.1406p AD=0.2516p
+ PS=1.12u PD=2.16u
M$509 \$969 \$100 \$970 VSS sg13_lv_nmos L=0.13u W=0.74u AS=0.2516p AD=0.1406p
+ PS=2.16u PD=1.12u
M$510 \$970 \$968 \$895 VSS sg13_lv_nmos L=0.13u W=0.74u AS=0.1406p AD=0.2516p
+ PS=1.12u PD=2.16u
M$511 VSS \$970 \$971 VSS sg13_lv_nmos L=0.13u W=0.74u AS=0.2516p AD=0.2516p
+ PS=2.16u PD=2.16u
M$512 VSS \$971 \$896 VSS sg13_lv_nmos L=0.13u W=0.74u AS=0.2516p AD=0.1406p
+ PS=2.16u PD=1.12u
M$513 \$896 \$855 \$897 VSS sg13_lv_nmos L=0.13u W=0.74u AS=0.1406p AD=0.1406p
+ PS=1.12u PD=1.12u
M$514 \$897 CLK \$898 VSS sg13_lv_nmos L=0.13u W=0.74u AS=0.1406p AD=0.1406p
+ PS=1.12u PD=1.12u
M$515 \$898 \$899 VSS VSS sg13_lv_nmos L=0.13u W=0.74u AS=0.1406p AD=0.2516p
+ PS=1.12u PD=2.16u
M$516 VSS \$897 \$899 VSS sg13_lv_nmos L=0.13u W=0.74u AS=0.2516p AD=0.1406p
+ PS=2.16u PD=1.12u
M$517 \$899 CLK \$900 VSS sg13_lv_nmos L=0.13u W=0.74u AS=0.1406p AD=0.1406p
+ PS=1.12u PD=1.12u
M$518 \$900 \$855 \$901 VSS sg13_lv_nmos L=0.13u W=0.74u AS=0.1406p AD=0.1406p
+ PS=1.12u PD=1.12u
M$519 \$901 \$902 VSS VSS sg13_lv_nmos L=0.13u W=0.74u AS=0.1406p AD=0.2516p
+ PS=1.12u PD=2.16u
M$520 VSS \$900 \$902 VSS sg13_lv_nmos L=0.13u W=0.74u AS=0.2516p AD=0.2516p
+ PS=2.16u PD=2.16u
M$521 VSS \$902 \$607 VSS sg13_lv_nmos L=0.13u W=0.74u AS=0.2516p AD=0.2516p
+ PS=2.16u PD=2.16u
M$522 VSS CLK \$855 VSS sg13_lv_nmos L=0.13u W=0.74u AS=0.2516p AD=0.2516p
+ PS=2.16u PD=2.16u
M$523 \$1213 \$1263 VSS VSS sg13_lv_nmos L=0.13u W=0.74u AS=0.3663p AD=0.2516p
+ PS=2.47u PD=2.16u
M$524 VSS C \$1189 VSS sg13_lv_nmos L=0.13u W=0.74u AS=0.2516p AD=0.33115p
+ PS=2.16u PD=1.635u
M$525 \$1189 B \$1190 VSS sg13_lv_nmos L=0.13u W=0.74u AS=0.33115p AD=0.33115p
+ PS=1.635u PD=1.635u
M$526 \$1190 \$1188 \$1096 VSS sg13_lv_nmos L=0.13u W=0.74u AS=0.33115p
+ AD=0.2516p PS=1.635u PD=2.16u
M$527 VSS \$1294 \$1313 VSS sg13_lv_nmos L=0.13u W=0.74u AS=0.2516p AD=0.33115p
+ PS=2.16u PD=1.635u
M$528 \$1313 \$1213 \$256 VSS sg13_lv_nmos L=0.13u W=0.74u AS=0.33115p
+ AD=0.33115p PS=1.635u PD=1.635u
M$529 \$256 \$1313 \$1314 VSS sg13_lv_nmos L=0.13u W=0.74u AS=0.33115p
+ AD=0.33115p PS=1.635u PD=1.635u
M$530 \$1314 \$1294 \$258 VSS sg13_lv_nmos L=0.13u W=0.74u AS=0.33115p
+ AD=0.33115p PS=1.635u PD=1.635u
M$531 \$258 \$1213 \$1294 VSS sg13_lv_nmos L=0.13u W=0.74u AS=0.33115p
+ AD=0.2516p PS=1.635u PD=2.16u
M$532 \$1295 \$1314 \$1315 VSS sg13_lv_nmos L=0.13u W=0.74u AS=0.2516p
+ AD=0.33115p PS=2.16u PD=1.635u
M$533 \$1315 Veval VSS VSS sg13_lv_nmos L=0.13u W=0.74u AS=0.33115p AD=0.2516p
+ PS=1.635u PD=2.16u
M$534 \$1294 \$1313 VSS VSS sg13_lv_nmos L=0.13u W=0.74u AS=0.2516p AD=0.2516p
+ PS=2.16u PD=2.16u
M$535 VSS \$1296 \$1316 VSS sg13_lv_nmos L=0.13u W=0.74u AS=0.2516p AD=0.33115p
+ PS=2.16u PD=1.635u
M$536 \$1316 \$1213 \$261 VSS sg13_lv_nmos L=0.13u W=0.74u AS=0.33115p
+ AD=0.33115p PS=1.635u PD=1.635u
M$537 \$261 \$1316 \$1317 VSS sg13_lv_nmos L=0.13u W=0.74u AS=0.33115p
+ AD=0.33115p PS=1.635u PD=1.635u
M$538 \$1317 \$1296 \$263 VSS sg13_lv_nmos L=0.13u W=0.74u AS=0.33115p
+ AD=0.33115p PS=1.635u PD=1.635u
M$539 \$263 \$1213 \$1296 VSS sg13_lv_nmos L=0.13u W=0.74u AS=0.33115p
+ AD=0.2516p PS=1.635u PD=2.16u
M$540 \$1295 \$1317 \$1318 VSS sg13_lv_nmos L=0.13u W=0.74u AS=0.2516p
+ AD=0.33115p PS=2.16u PD=1.635u
M$541 \$1318 Veval VSS VSS sg13_lv_nmos L=0.13u W=0.74u AS=0.33115p AD=0.2516p
+ PS=1.635u PD=2.16u
M$542 \$1296 \$1316 VSS VSS sg13_lv_nmos L=0.13u W=0.74u AS=0.2516p AD=0.2516p
+ PS=2.16u PD=2.16u
M$543 VSS \$1297 \$1319 VSS sg13_lv_nmos L=0.13u W=0.74u AS=0.2516p AD=0.33115p
+ PS=2.16u PD=1.635u
M$544 \$1319 \$1213 \$266 VSS sg13_lv_nmos L=0.13u W=0.74u AS=0.33115p
+ AD=0.33115p PS=1.635u PD=1.635u
M$545 \$266 \$1319 \$1320 VSS sg13_lv_nmos L=0.13u W=0.74u AS=0.33115p
+ AD=0.33115p PS=1.635u PD=1.635u
M$546 \$1320 \$1297 \$268 VSS sg13_lv_nmos L=0.13u W=0.74u AS=0.33115p
+ AD=0.33115p PS=1.635u PD=1.635u
M$547 \$268 \$1213 \$1297 VSS sg13_lv_nmos L=0.13u W=0.74u AS=0.33115p
+ AD=0.2516p PS=1.635u PD=2.16u
M$548 \$1295 \$1320 \$1321 VSS sg13_lv_nmos L=0.13u W=0.74u AS=0.2516p
+ AD=0.33115p PS=2.16u PD=1.635u
M$549 \$1321 Veval VSS VSS sg13_lv_nmos L=0.13u W=0.74u AS=0.33115p AD=0.2516p
+ PS=1.635u PD=2.16u
M$550 \$1297 \$1319 VSS VSS sg13_lv_nmos L=0.13u W=0.74u AS=0.2516p AD=0.2516p
+ PS=2.16u PD=2.16u
M$551 VSS \$1298 \$1322 VSS sg13_lv_nmos L=0.13u W=0.74u AS=0.2516p AD=0.33115p
+ PS=2.16u PD=1.635u
M$552 \$1322 \$1213 \$271 VSS sg13_lv_nmos L=0.13u W=0.74u AS=0.33115p
+ AD=0.33115p PS=1.635u PD=1.635u
M$553 \$271 \$1322 \$1323 VSS sg13_lv_nmos L=0.13u W=0.74u AS=0.33115p
+ AD=0.33115p PS=1.635u PD=1.635u
M$554 \$1323 \$1298 \$273 VSS sg13_lv_nmos L=0.13u W=0.74u AS=0.33115p
+ AD=0.33115p PS=1.635u PD=1.635u
M$555 \$273 \$1213 \$1298 VSS sg13_lv_nmos L=0.13u W=0.74u AS=0.33115p
+ AD=0.2516p PS=1.635u PD=2.16u
M$556 \$1295 \$1323 \$1324 VSS sg13_lv_nmos L=0.13u W=0.74u AS=0.2516p
+ AD=0.33115p PS=2.16u PD=1.635u
M$557 \$1324 Veval VSS VSS sg13_lv_nmos L=0.13u W=0.74u AS=0.33115p AD=0.2516p
+ PS=1.635u PD=2.16u
M$558 \$1298 \$1322 VSS VSS sg13_lv_nmos L=0.13u W=0.74u AS=0.2516p AD=0.2516p
+ PS=2.16u PD=2.16u
M$559 VSS \$1299 \$1325 VSS sg13_lv_nmos L=0.13u W=0.74u AS=0.2516p AD=0.33115p
+ PS=2.16u PD=1.635u
M$560 \$1325 \$1213 \$276 VSS sg13_lv_nmos L=0.13u W=0.74u AS=0.33115p
+ AD=0.33115p PS=1.635u PD=1.635u
M$561 \$276 \$1325 \$1326 VSS sg13_lv_nmos L=0.13u W=0.74u AS=0.33115p
+ AD=0.33115p PS=1.635u PD=1.635u
M$562 \$1326 \$1299 \$278 VSS sg13_lv_nmos L=0.13u W=0.74u AS=0.33115p
+ AD=0.33115p PS=1.635u PD=1.635u
M$563 \$278 \$1213 \$1299 VSS sg13_lv_nmos L=0.13u W=0.74u AS=0.33115p
+ AD=0.2516p PS=1.635u PD=2.16u
M$564 \$1295 \$1326 \$1327 VSS sg13_lv_nmos L=0.13u W=0.74u AS=0.2516p
+ AD=0.33115p PS=2.16u PD=1.635u
M$565 \$1327 Veval VSS VSS sg13_lv_nmos L=0.13u W=0.74u AS=0.33115p AD=0.2516p
+ PS=1.635u PD=2.16u
M$566 \$1299 \$1325 VSS VSS sg13_lv_nmos L=0.13u W=0.74u AS=0.2516p AD=0.2516p
+ PS=2.16u PD=2.16u
M$567 VSS \$1300 \$1328 VSS sg13_lv_nmos L=0.13u W=0.74u AS=0.2516p AD=0.33115p
+ PS=2.16u PD=1.635u
M$568 \$1328 \$1213 \$281 VSS sg13_lv_nmos L=0.13u W=0.74u AS=0.33115p
+ AD=0.33115p PS=1.635u PD=1.635u
M$569 \$281 \$1328 \$1329 VSS sg13_lv_nmos L=0.13u W=0.74u AS=0.33115p
+ AD=0.33115p PS=1.635u PD=1.635u
M$570 \$1329 \$1300 \$283 VSS sg13_lv_nmos L=0.13u W=0.74u AS=0.33115p
+ AD=0.33115p PS=1.635u PD=1.635u
M$571 \$283 \$1213 \$1300 VSS sg13_lv_nmos L=0.13u W=0.74u AS=0.33115p
+ AD=0.2516p PS=1.635u PD=2.16u
M$572 \$1295 \$1329 \$1330 VSS sg13_lv_nmos L=0.13u W=0.74u AS=0.2516p
+ AD=0.33115p PS=2.16u PD=1.635u
M$573 \$1330 Veval VSS VSS sg13_lv_nmos L=0.13u W=0.74u AS=0.33115p AD=0.2516p
+ PS=1.635u PD=2.16u
M$574 \$1300 \$1328 VSS VSS sg13_lv_nmos L=0.13u W=0.74u AS=0.2516p AD=0.2516p
+ PS=2.16u PD=2.16u
M$575 VSS \$1301 \$1331 VSS sg13_lv_nmos L=0.13u W=0.74u AS=0.2516p AD=0.33115p
+ PS=2.16u PD=1.635u
M$576 \$1331 \$1213 \$286 VSS sg13_lv_nmos L=0.13u W=0.74u AS=0.33115p
+ AD=0.33115p PS=1.635u PD=1.635u
M$577 \$286 \$1331 \$1332 VSS sg13_lv_nmos L=0.13u W=0.74u AS=0.33115p
+ AD=0.33115p PS=1.635u PD=1.635u
M$578 \$1332 \$1301 \$288 VSS sg13_lv_nmos L=0.13u W=0.74u AS=0.33115p
+ AD=0.33115p PS=1.635u PD=1.635u
M$579 \$288 \$1213 \$1301 VSS sg13_lv_nmos L=0.13u W=0.74u AS=0.33115p
+ AD=0.2516p PS=1.635u PD=2.16u
M$580 \$1295 \$1332 \$1333 VSS sg13_lv_nmos L=0.13u W=0.74u AS=0.2516p
+ AD=0.33115p PS=2.16u PD=1.635u
M$581 \$1333 Veval VSS VSS sg13_lv_nmos L=0.13u W=0.74u AS=0.33115p AD=0.2516p
+ PS=1.635u PD=2.16u
M$582 \$1301 \$1331 VSS VSS sg13_lv_nmos L=0.13u W=0.74u AS=0.2516p AD=0.2516p
+ PS=2.16u PD=2.16u
M$583 VSS \$1302 \$1334 VSS sg13_lv_nmos L=0.13u W=0.74u AS=0.2516p AD=0.33115p
+ PS=2.16u PD=1.635u
M$584 \$1334 \$1213 \$291 VSS sg13_lv_nmos L=0.13u W=0.74u AS=0.33115p
+ AD=0.33115p PS=1.635u PD=1.635u
M$585 \$291 \$1334 \$1335 VSS sg13_lv_nmos L=0.13u W=0.74u AS=0.33115p
+ AD=0.33115p PS=1.635u PD=1.635u
M$586 \$1335 \$1302 \$293 VSS sg13_lv_nmos L=0.13u W=0.74u AS=0.33115p
+ AD=0.33115p PS=1.635u PD=1.635u
M$587 \$293 \$1213 \$1302 VSS sg13_lv_nmos L=0.13u W=0.74u AS=0.33115p
+ AD=0.2516p PS=1.635u PD=2.16u
M$588 \$1295 \$1335 \$1336 VSS sg13_lv_nmos L=0.13u W=0.74u AS=0.2516p
+ AD=0.33115p PS=2.16u PD=1.635u
M$589 \$1336 Veval VSS VSS sg13_lv_nmos L=0.13u W=0.74u AS=0.33115p AD=0.2516p
+ PS=1.635u PD=2.16u
M$590 \$1302 \$1334 VSS VSS sg13_lv_nmos L=0.13u W=0.74u AS=0.2516p AD=0.2516p
+ PS=2.16u PD=2.16u
M$591 VSS \$1405 \$1303 VSS sg13_lv_nmos L=0.13u W=2.96u AS=1.0064p AD=1.0064p
+ PS=6.6u PD=6.6u
M$592 VSS \$1337 \$1304 VSS sg13_lv_nmos L=0.13u W=2.96u AS=1.0064p AD=1.0064p
+ PS=6.6u PD=6.6u
M$593 VSS \$1408 \$1214 VSS sg13_lv_nmos L=0.13u W=0.74u AS=0.2516p AD=0.1406p
+ PS=2.16u PD=1.12u
M$594 \$1214 \$1121 \$1215 VSS sg13_lv_nmos L=0.13u W=0.74u AS=0.1406p
+ AD=0.1406p PS=1.12u PD=1.12u
M$595 \$1215 CLK \$1216 VSS sg13_lv_nmos L=0.13u W=0.74u AS=0.1406p AD=0.1406p
+ PS=1.12u PD=1.12u
M$596 \$1216 \$1217 VSS VSS sg13_lv_nmos L=0.13u W=0.74u AS=0.1406p AD=0.2516p
+ PS=1.12u PD=2.16u
M$597 VSS \$1215 \$1217 VSS sg13_lv_nmos L=0.13u W=0.74u AS=0.2516p AD=0.1406p
+ PS=2.16u PD=1.12u
M$598 \$1217 CLK \$1218 VSS sg13_lv_nmos L=0.13u W=0.74u AS=0.1406p AD=0.1406p
+ PS=1.12u PD=1.12u
M$599 \$1218 \$1121 \$1219 VSS sg13_lv_nmos L=0.13u W=0.74u AS=0.1406p
+ AD=0.1406p PS=1.12u PD=1.12u
M$600 \$1219 \$1220 VSS VSS sg13_lv_nmos L=0.13u W=0.74u AS=0.1406p AD=0.2516p
+ PS=1.12u PD=2.16u
M$601 VSS \$1218 \$1220 VSS sg13_lv_nmos L=0.13u W=0.74u AS=0.2516p AD=0.2516p
+ PS=2.16u PD=2.16u
M$602 VSS \$1220 \$1221 VSS sg13_lv_nmos L=0.13u W=0.74u AS=0.2516p AD=0.2516p
+ PS=2.16u PD=2.16u
M$603 VSS CLK \$1121 VSS sg13_lv_nmos L=0.13u W=0.74u AS=0.2516p AD=0.2516p
+ PS=2.16u PD=2.16u
M$604 VSS \$100 \$1222 VSS sg13_lv_nmos L=0.13u W=0.74u AS=0.2516p AD=0.2516p
+ PS=2.16u PD=2.16u
M$605 \$1223 \$1221 VSS VSS sg13_lv_nmos L=0.13u W=0.74u AS=0.2516p AD=0.1406p
+ PS=2.16u PD=1.12u
M$606 VSS \$1122 \$1191 VSS sg13_lv_nmos L=0.13u W=0.74u AS=0.1406p AD=0.2516p
+ PS=1.12u PD=2.16u
M$607 \$1223 \$100 \$1224 VSS sg13_lv_nmos L=0.13u W=0.74u AS=0.2516p
+ AD=0.1406p PS=2.16u PD=1.12u
M$608 \$1224 \$1222 \$1191 VSS sg13_lv_nmos L=0.13u W=0.74u AS=0.1406p
+ AD=0.2516p PS=1.12u PD=2.16u
M$609 VSS \$1224 \$1225 VSS sg13_lv_nmos L=0.13u W=0.74u AS=0.2516p AD=0.2516p
+ PS=2.16u PD=2.16u
M$610 VSS \$1225 \$1226 VSS sg13_lv_nmos L=0.13u W=0.74u AS=0.2516p AD=0.1406p
+ PS=2.16u PD=1.12u
M$611 \$1226 \$1123 \$1227 VSS sg13_lv_nmos L=0.13u W=0.74u AS=0.1406p
+ AD=0.1406p PS=1.12u PD=1.12u
M$612 \$1227 CLK \$1228 VSS sg13_lv_nmos L=0.13u W=0.74u AS=0.1406p AD=0.1406p
+ PS=1.12u PD=1.12u
M$613 \$1228 \$1229 VSS VSS sg13_lv_nmos L=0.13u W=0.74u AS=0.1406p AD=0.2516p
+ PS=1.12u PD=2.16u
M$614 VSS \$1227 \$1229 VSS sg13_lv_nmos L=0.13u W=0.74u AS=0.2516p AD=0.1406p
+ PS=2.16u PD=1.12u
M$615 \$1229 CLK \$1230 VSS sg13_lv_nmos L=0.13u W=0.74u AS=0.1406p AD=0.1406p
+ PS=1.12u PD=1.12u
M$616 \$1230 \$1123 \$1231 VSS sg13_lv_nmos L=0.13u W=0.74u AS=0.1406p
+ AD=0.1406p PS=1.12u PD=1.12u
M$617 \$1231 \$1232 VSS VSS sg13_lv_nmos L=0.13u W=0.74u AS=0.1406p AD=0.2516p
+ PS=1.12u PD=2.16u
M$618 VSS \$1230 \$1232 VSS sg13_lv_nmos L=0.13u W=0.74u AS=0.2516p AD=0.2516p
+ PS=2.16u PD=2.16u
M$619 VSS \$1232 \$854 VSS sg13_lv_nmos L=0.13u W=0.74u AS=0.2516p AD=0.2516p
+ PS=2.16u PD=2.16u
M$620 VSS CLK \$1123 VSS sg13_lv_nmos L=0.13u W=0.74u AS=0.2516p AD=0.2516p
+ PS=2.16u PD=2.16u
M$621 VSS C \$572 VSS sg13_lv_nmos L=0.13u W=0.74u AS=0.3663p AD=0.2516p
+ PS=2.47u PD=2.16u
M$622 \$1442 \$1453 VSS VSS sg13_lv_nmos L=0.13u W=0.74u AS=0.3663p AD=0.2516p
+ PS=2.47u PD=2.16u
M$623 VSS \$572 \$1309 VSS sg13_lv_nmos L=0.13u W=0.74u AS=0.2516p AD=0.33115p
+ PS=2.16u PD=1.635u
M$624 \$1309 B \$1404 VSS sg13_lv_nmos L=0.13u W=0.74u AS=0.33115p AD=0.33115p
+ PS=1.635u PD=1.635u
M$625 \$1404 \$1188 \$1263 VSS sg13_lv_nmos L=0.13u W=0.74u AS=0.33115p
+ AD=0.2516p PS=1.635u PD=2.16u
M$626 VSS C \$1518 VSS sg13_lv_nmos L=0.13u W=0.74u AS=0.2516p AD=0.33115p
+ PS=2.16u PD=1.635u
M$627 \$1518 \$786 \$1575 VSS sg13_lv_nmos L=0.13u W=0.74u AS=0.33115p
+ AD=0.33115p PS=1.635u PD=1.635u
M$628 \$1575 \$1188 \$1453 VSS sg13_lv_nmos L=0.13u W=0.74u AS=0.33115p
+ AD=0.2516p PS=1.635u PD=2.16u
M$629 VSS \$1508 \$1521 VSS sg13_lv_nmos L=0.13u W=0.74u AS=0.2516p AD=0.33115p
+ PS=2.16u PD=1.635u
M$630 \$1521 \$1442 \$256 VSS sg13_lv_nmos L=0.13u W=0.74u AS=0.33115p
+ AD=0.33115p PS=1.635u PD=1.635u
M$631 \$256 \$1521 \$1522 VSS sg13_lv_nmos L=0.13u W=0.74u AS=0.33115p
+ AD=0.33115p PS=1.635u PD=1.635u
M$632 \$1522 \$1508 \$258 VSS sg13_lv_nmos L=0.13u W=0.74u AS=0.33115p
+ AD=0.33115p PS=1.635u PD=1.635u
M$633 \$258 \$1442 \$1508 VSS sg13_lv_nmos L=0.13u W=0.74u AS=0.33115p
+ AD=0.2516p PS=1.635u PD=2.16u
M$634 \$1473 \$1522 \$1523 VSS sg13_lv_nmos L=0.13u W=0.74u AS=0.2516p
+ AD=0.33115p PS=2.16u PD=1.635u
M$635 \$1523 Veval VSS VSS sg13_lv_nmos L=0.13u W=0.74u AS=0.33115p AD=0.2516p
+ PS=1.635u PD=2.16u
M$636 \$1508 \$1521 VSS VSS sg13_lv_nmos L=0.13u W=0.74u AS=0.2516p AD=0.2516p
+ PS=2.16u PD=2.16u
M$637 VSS \$1509 \$1524 VSS sg13_lv_nmos L=0.13u W=0.74u AS=0.2516p AD=0.33115p
+ PS=2.16u PD=1.635u
M$638 \$1524 \$1442 \$261 VSS sg13_lv_nmos L=0.13u W=0.74u AS=0.33115p
+ AD=0.33115p PS=1.635u PD=1.635u
M$639 \$261 \$1524 \$1525 VSS sg13_lv_nmos L=0.13u W=0.74u AS=0.33115p
+ AD=0.33115p PS=1.635u PD=1.635u
M$640 \$1525 \$1509 \$263 VSS sg13_lv_nmos L=0.13u W=0.74u AS=0.33115p
+ AD=0.33115p PS=1.635u PD=1.635u
M$641 \$263 \$1442 \$1509 VSS sg13_lv_nmos L=0.13u W=0.74u AS=0.33115p
+ AD=0.2516p PS=1.635u PD=2.16u
M$642 \$1473 \$1525 \$1526 VSS sg13_lv_nmos L=0.13u W=0.74u AS=0.2516p
+ AD=0.33115p PS=2.16u PD=1.635u
M$643 \$1526 Veval VSS VSS sg13_lv_nmos L=0.13u W=0.74u AS=0.33115p AD=0.2516p
+ PS=1.635u PD=2.16u
M$644 \$1509 \$1524 VSS VSS sg13_lv_nmos L=0.13u W=0.74u AS=0.2516p AD=0.2516p
+ PS=2.16u PD=2.16u
M$645 VSS \$1510 \$1527 VSS sg13_lv_nmos L=0.13u W=0.74u AS=0.2516p AD=0.33115p
+ PS=2.16u PD=1.635u
M$646 \$1527 \$1442 \$266 VSS sg13_lv_nmos L=0.13u W=0.74u AS=0.33115p
+ AD=0.33115p PS=1.635u PD=1.635u
M$647 \$266 \$1527 \$1528 VSS sg13_lv_nmos L=0.13u W=0.74u AS=0.33115p
+ AD=0.33115p PS=1.635u PD=1.635u
M$648 \$1528 \$1510 \$268 VSS sg13_lv_nmos L=0.13u W=0.74u AS=0.33115p
+ AD=0.33115p PS=1.635u PD=1.635u
M$649 \$268 \$1442 \$1510 VSS sg13_lv_nmos L=0.13u W=0.74u AS=0.33115p
+ AD=0.2516p PS=1.635u PD=2.16u
M$650 \$1473 \$1528 \$1529 VSS sg13_lv_nmos L=0.13u W=0.74u AS=0.2516p
+ AD=0.33115p PS=2.16u PD=1.635u
M$651 \$1529 Veval VSS VSS sg13_lv_nmos L=0.13u W=0.74u AS=0.33115p AD=0.2516p
+ PS=1.635u PD=2.16u
M$652 \$1510 \$1527 VSS VSS sg13_lv_nmos L=0.13u W=0.74u AS=0.2516p AD=0.2516p
+ PS=2.16u PD=2.16u
M$653 VSS \$1511 \$1530 VSS sg13_lv_nmos L=0.13u W=0.74u AS=0.2516p AD=0.33115p
+ PS=2.16u PD=1.635u
M$654 \$1530 \$1442 \$271 VSS sg13_lv_nmos L=0.13u W=0.74u AS=0.33115p
+ AD=0.33115p PS=1.635u PD=1.635u
M$655 \$271 \$1530 \$1531 VSS sg13_lv_nmos L=0.13u W=0.74u AS=0.33115p
+ AD=0.33115p PS=1.635u PD=1.635u
M$656 \$1531 \$1511 \$273 VSS sg13_lv_nmos L=0.13u W=0.74u AS=0.33115p
+ AD=0.33115p PS=1.635u PD=1.635u
M$657 \$273 \$1442 \$1511 VSS sg13_lv_nmos L=0.13u W=0.74u AS=0.33115p
+ AD=0.2516p PS=1.635u PD=2.16u
M$658 \$1473 \$1531 \$1532 VSS sg13_lv_nmos L=0.13u W=0.74u AS=0.2516p
+ AD=0.33115p PS=2.16u PD=1.635u
M$659 \$1532 Veval VSS VSS sg13_lv_nmos L=0.13u W=0.74u AS=0.33115p AD=0.2516p
+ PS=1.635u PD=2.16u
M$660 \$1511 \$1530 VSS VSS sg13_lv_nmos L=0.13u W=0.74u AS=0.2516p AD=0.2516p
+ PS=2.16u PD=2.16u
M$661 VSS \$1512 \$1533 VSS sg13_lv_nmos L=0.13u W=0.74u AS=0.2516p AD=0.33115p
+ PS=2.16u PD=1.635u
M$662 \$1533 \$1442 \$276 VSS sg13_lv_nmos L=0.13u W=0.74u AS=0.33115p
+ AD=0.33115p PS=1.635u PD=1.635u
M$663 \$276 \$1533 \$1534 VSS sg13_lv_nmos L=0.13u W=0.74u AS=0.33115p
+ AD=0.33115p PS=1.635u PD=1.635u
M$664 \$1534 \$1512 \$278 VSS sg13_lv_nmos L=0.13u W=0.74u AS=0.33115p
+ AD=0.33115p PS=1.635u PD=1.635u
M$665 \$278 \$1442 \$1512 VSS sg13_lv_nmos L=0.13u W=0.74u AS=0.33115p
+ AD=0.2516p PS=1.635u PD=2.16u
M$666 \$1473 \$1534 \$1535 VSS sg13_lv_nmos L=0.13u W=0.74u AS=0.2516p
+ AD=0.33115p PS=2.16u PD=1.635u
M$667 \$1535 Veval VSS VSS sg13_lv_nmos L=0.13u W=0.74u AS=0.33115p AD=0.2516p
+ PS=1.635u PD=2.16u
M$668 \$1512 \$1533 VSS VSS sg13_lv_nmos L=0.13u W=0.74u AS=0.2516p AD=0.2516p
+ PS=2.16u PD=2.16u
M$669 VSS \$1513 \$1536 VSS sg13_lv_nmos L=0.13u W=0.74u AS=0.2516p AD=0.33115p
+ PS=2.16u PD=1.635u
M$670 \$1536 \$1442 \$281 VSS sg13_lv_nmos L=0.13u W=0.74u AS=0.33115p
+ AD=0.33115p PS=1.635u PD=1.635u
M$671 \$281 \$1536 \$1537 VSS sg13_lv_nmos L=0.13u W=0.74u AS=0.33115p
+ AD=0.33115p PS=1.635u PD=1.635u
M$672 \$1537 \$1513 \$283 VSS sg13_lv_nmos L=0.13u W=0.74u AS=0.33115p
+ AD=0.33115p PS=1.635u PD=1.635u
M$673 \$283 \$1442 \$1513 VSS sg13_lv_nmos L=0.13u W=0.74u AS=0.33115p
+ AD=0.2516p PS=1.635u PD=2.16u
M$674 \$1473 \$1537 \$1538 VSS sg13_lv_nmos L=0.13u W=0.74u AS=0.2516p
+ AD=0.33115p PS=2.16u PD=1.635u
M$675 \$1538 Veval VSS VSS sg13_lv_nmos L=0.13u W=0.74u AS=0.33115p AD=0.2516p
+ PS=1.635u PD=2.16u
M$676 \$1513 \$1536 VSS VSS sg13_lv_nmos L=0.13u W=0.74u AS=0.2516p AD=0.2516p
+ PS=2.16u PD=2.16u
M$677 VSS \$1514 \$1539 VSS sg13_lv_nmos L=0.13u W=0.74u AS=0.2516p AD=0.33115p
+ PS=2.16u PD=1.635u
M$678 \$1539 \$1442 \$286 VSS sg13_lv_nmos L=0.13u W=0.74u AS=0.33115p
+ AD=0.33115p PS=1.635u PD=1.635u
M$679 \$286 \$1539 \$1540 VSS sg13_lv_nmos L=0.13u W=0.74u AS=0.33115p
+ AD=0.33115p PS=1.635u PD=1.635u
M$680 \$1540 \$1514 \$288 VSS sg13_lv_nmos L=0.13u W=0.74u AS=0.33115p
+ AD=0.33115p PS=1.635u PD=1.635u
M$681 \$288 \$1442 \$1514 VSS sg13_lv_nmos L=0.13u W=0.74u AS=0.33115p
+ AD=0.2516p PS=1.635u PD=2.16u
M$682 \$1473 \$1540 \$1541 VSS sg13_lv_nmos L=0.13u W=0.74u AS=0.2516p
+ AD=0.33115p PS=2.16u PD=1.635u
M$683 \$1541 Veval VSS VSS sg13_lv_nmos L=0.13u W=0.74u AS=0.33115p AD=0.2516p
+ PS=1.635u PD=2.16u
M$684 \$1514 \$1539 VSS VSS sg13_lv_nmos L=0.13u W=0.74u AS=0.2516p AD=0.2516p
+ PS=2.16u PD=2.16u
M$685 VSS \$1515 \$1542 VSS sg13_lv_nmos L=0.13u W=0.74u AS=0.2516p AD=0.33115p
+ PS=2.16u PD=1.635u
M$686 \$1542 \$1442 \$291 VSS sg13_lv_nmos L=0.13u W=0.74u AS=0.33115p
+ AD=0.33115p PS=1.635u PD=1.635u
M$687 \$291 \$1542 \$1543 VSS sg13_lv_nmos L=0.13u W=0.74u AS=0.33115p
+ AD=0.33115p PS=1.635u PD=1.635u
M$688 \$1543 \$1515 \$293 VSS sg13_lv_nmos L=0.13u W=0.74u AS=0.33115p
+ AD=0.33115p PS=1.635u PD=1.635u
M$689 \$293 \$1442 \$1515 VSS sg13_lv_nmos L=0.13u W=0.74u AS=0.33115p
+ AD=0.2516p PS=1.635u PD=2.16u
M$690 \$1473 \$1543 \$1544 VSS sg13_lv_nmos L=0.13u W=0.74u AS=0.2516p
+ AD=0.33115p PS=2.16u PD=1.635u
M$691 \$1544 Veval VSS VSS sg13_lv_nmos L=0.13u W=0.74u AS=0.33115p AD=0.2516p
+ PS=1.635u PD=2.16u
M$692 \$1515 \$1542 VSS VSS sg13_lv_nmos L=0.13u W=0.74u AS=0.2516p AD=0.2516p
+ PS=2.16u PD=2.16u
M$693 VSS Veval \$1405 VSS sg13_lv_nmos L=0.13u W=0.74u AS=0.2516p AD=0.2516p
+ PS=2.16u PD=2.16u
M$694 VSS \$1303 \$1337 VSS sg13_lv_nmos L=0.13u W=0.74u AS=0.2516p AD=0.2516p
+ PS=2.16u PD=2.16u
M$695 \$1295 \$1337 \$1406 VSS sg13_lv_nmos L=0.13u W=0.74u AS=0.2516p
+ AD=0.2516p PS=2.16u PD=2.16u
M$696 VSS \$1406 \$1407 VSS sg13_lv_nmos L=0.13u W=0.74u AS=0.2516p AD=0.2516p
+ PS=2.16u PD=2.16u
M$697 VSS \$1407 \$1408 VSS sg13_lv_nmos L=0.13u W=0.74u AS=0.2516p AD=0.2516p
+ PS=2.16u PD=2.16u
M$698 \$1406 \$1304 \$1409 VSS sg13_lv_nmos L=0.13u W=0.74u AS=0.2516p
+ AD=0.2516p PS=2.16u PD=2.16u
M$699 \$1409 \$1407 VSS VSS sg13_lv_nmos L=0.13u W=0.74u AS=0.2516p AD=0.2516p
+ PS=2.16u PD=2.16u
M$700 VSS \$1700 \$1454 VSS sg13_lv_nmos L=0.13u W=0.74u AS=0.2516p AD=0.1406p
+ PS=2.16u PD=1.12u
M$701 \$1454 \$1443 \$1455 VSS sg13_lv_nmos L=0.13u W=0.74u AS=0.1406p
+ AD=0.1406p PS=1.12u PD=1.12u
M$702 \$1455 CLK \$1456 VSS sg13_lv_nmos L=0.13u W=0.74u AS=0.1406p AD=0.1406p
+ PS=1.12u PD=1.12u
M$703 \$1456 \$1457 VSS VSS sg13_lv_nmos L=0.13u W=0.74u AS=0.1406p AD=0.2516p
+ PS=1.12u PD=2.16u
M$704 VSS \$1455 \$1457 VSS sg13_lv_nmos L=0.13u W=0.74u AS=0.2516p AD=0.1406p
+ PS=2.16u PD=1.12u
M$705 \$1457 CLK \$1458 VSS sg13_lv_nmos L=0.13u W=0.74u AS=0.1406p AD=0.1406p
+ PS=1.12u PD=1.12u
M$706 \$1458 \$1443 \$1459 VSS sg13_lv_nmos L=0.13u W=0.74u AS=0.1406p
+ AD=0.1406p PS=1.12u PD=1.12u
M$707 \$1459 \$1460 VSS VSS sg13_lv_nmos L=0.13u W=0.74u AS=0.1406p AD=0.2516p
+ PS=1.12u PD=2.16u
M$708 VSS \$1458 \$1460 VSS sg13_lv_nmos L=0.13u W=0.74u AS=0.2516p AD=0.2516p
+ PS=2.16u PD=2.16u
M$709 VSS \$1460 \$1461 VSS sg13_lv_nmos L=0.13u W=0.74u AS=0.2516p AD=0.2516p
+ PS=2.16u PD=2.16u
M$710 VSS CLK \$1443 VSS sg13_lv_nmos L=0.13u W=0.74u AS=0.2516p AD=0.2516p
+ PS=2.16u PD=2.16u
M$711 VSS \$100 \$1474 VSS sg13_lv_nmos L=0.13u W=0.74u AS=0.2516p AD=0.2516p
+ PS=2.16u PD=2.16u
M$712 \$1475 \$1461 VSS VSS sg13_lv_nmos L=0.13u W=0.74u AS=0.2516p AD=0.1406p
+ PS=2.16u PD=1.12u
M$713 VSS \$1410 \$1445 VSS sg13_lv_nmos L=0.13u W=0.74u AS=0.1406p AD=0.2516p
+ PS=1.12u PD=2.16u
M$714 \$1475 \$100 \$1476 VSS sg13_lv_nmos L=0.13u W=0.74u AS=0.2516p
+ AD=0.1406p PS=2.16u PD=1.12u
M$715 \$1476 \$1474 \$1445 VSS sg13_lv_nmos L=0.13u W=0.74u AS=0.1406p
+ AD=0.2516p PS=1.12u PD=2.16u
M$716 VSS \$1476 \$1477 VSS sg13_lv_nmos L=0.13u W=0.74u AS=0.2516p AD=0.2516p
+ PS=2.16u PD=2.16u
M$717 VSS \$1477 \$1462 VSS sg13_lv_nmos L=0.13u W=0.74u AS=0.2516p AD=0.1406p
+ PS=2.16u PD=1.12u
M$718 \$1462 \$1444 \$1463 VSS sg13_lv_nmos L=0.13u W=0.74u AS=0.1406p
+ AD=0.1406p PS=1.12u PD=1.12u
M$719 \$1463 CLK \$1464 VSS sg13_lv_nmos L=0.13u W=0.74u AS=0.1406p AD=0.1406p
+ PS=1.12u PD=1.12u
M$720 \$1464 \$1465 VSS VSS sg13_lv_nmos L=0.13u W=0.74u AS=0.1406p AD=0.2516p
+ PS=1.12u PD=2.16u
M$721 VSS \$1463 \$1465 VSS sg13_lv_nmos L=0.13u W=0.74u AS=0.2516p AD=0.1406p
+ PS=2.16u PD=1.12u
M$722 \$1465 CLK \$1466 VSS sg13_lv_nmos L=0.13u W=0.74u AS=0.1406p AD=0.1406p
+ PS=1.12u PD=1.12u
M$723 \$1466 \$1444 \$1467 VSS sg13_lv_nmos L=0.13u W=0.74u AS=0.1406p
+ AD=0.1406p PS=1.12u PD=1.12u
M$724 \$1467 \$1468 VSS VSS sg13_lv_nmos L=0.13u W=0.74u AS=0.1406p AD=0.2516p
+ PS=1.12u PD=2.16u
M$725 VSS \$1466 \$1468 VSS sg13_lv_nmos L=0.13u W=0.74u AS=0.2516p AD=0.2516p
+ PS=2.16u PD=2.16u
M$726 VSS \$1468 \$1122 VSS sg13_lv_nmos L=0.13u W=0.74u AS=0.2516p AD=0.2516p
+ PS=2.16u PD=2.16u
M$727 VSS CLK \$1444 VSS sg13_lv_nmos L=0.13u W=0.74u AS=0.2516p AD=0.2516p
+ PS=2.16u PD=2.16u
M$728 VSS A \$1188 VSS sg13_lv_nmos L=0.13u W=0.74u AS=0.3663p AD=0.2516p
+ PS=2.47u PD=2.16u
M$729 VSS B \$786 VSS sg13_lv_nmos L=0.13u W=0.74u AS=0.3663p AD=0.2516p
+ PS=2.47u PD=2.16u
M$730 \$1643 \$1662 VSS VSS sg13_lv_nmos L=0.13u W=0.74u AS=0.3663p AD=0.2516p
+ PS=2.47u PD=2.16u
M$731 VSS \$572 \$1675 VSS sg13_lv_nmos L=0.13u W=0.74u AS=0.2516p AD=0.33115p
+ PS=2.16u PD=1.635u
M$732 \$1675 \$786 \$1696 VSS sg13_lv_nmos L=0.13u W=0.74u AS=0.33115p
+ AD=0.33115p PS=1.635u PD=1.635u
M$733 \$1696 \$1188 \$1662 VSS sg13_lv_nmos L=0.13u W=0.74u AS=0.33115p
+ AD=0.2516p PS=1.635u PD=2.16u
M$734 VSS \$1676 \$1742 VSS sg13_lv_nmos L=0.13u W=0.74u AS=0.2516p AD=0.33115p
+ PS=2.16u PD=1.635u
M$735 \$1742 \$1688 \$256 VSS sg13_lv_nmos L=0.13u W=0.74u AS=0.33115p
+ AD=0.33115p PS=1.635u PD=1.635u
M$736 \$256 \$1742 \$1743 VSS sg13_lv_nmos L=0.13u W=0.74u AS=0.33115p
+ AD=0.33115p PS=1.635u PD=1.635u
M$737 \$1743 \$1676 \$258 VSS sg13_lv_nmos L=0.13u W=0.74u AS=0.33115p
+ AD=0.33115p PS=1.635u PD=1.635u
M$738 \$258 \$1688 \$1676 VSS sg13_lv_nmos L=0.13u W=0.74u AS=0.33115p
+ AD=0.2516p PS=1.635u PD=2.16u
M$739 \$1677 \$1743 \$1744 VSS sg13_lv_nmos L=0.13u W=0.74u AS=0.2516p
+ AD=0.33115p PS=2.16u PD=1.635u
M$740 \$1744 Veval VSS VSS sg13_lv_nmos L=0.13u W=0.74u AS=0.33115p AD=0.2516p
+ PS=1.635u PD=2.16u
M$741 \$1676 \$1742 VSS VSS sg13_lv_nmos L=0.13u W=0.74u AS=0.2516p AD=0.2516p
+ PS=2.16u PD=2.16u
M$742 VSS \$1678 \$1745 VSS sg13_lv_nmos L=0.13u W=0.74u AS=0.2516p AD=0.33115p
+ PS=2.16u PD=1.635u
M$743 \$1745 \$1688 \$261 VSS sg13_lv_nmos L=0.13u W=0.74u AS=0.33115p
+ AD=0.33115p PS=1.635u PD=1.635u
M$744 \$261 \$1745 \$1746 VSS sg13_lv_nmos L=0.13u W=0.74u AS=0.33115p
+ AD=0.33115p PS=1.635u PD=1.635u
M$745 \$1746 \$1678 \$263 VSS sg13_lv_nmos L=0.13u W=0.74u AS=0.33115p
+ AD=0.33115p PS=1.635u PD=1.635u
M$746 \$263 \$1688 \$1678 VSS sg13_lv_nmos L=0.13u W=0.74u AS=0.33115p
+ AD=0.2516p PS=1.635u PD=2.16u
M$747 \$1677 \$1746 \$1747 VSS sg13_lv_nmos L=0.13u W=0.74u AS=0.2516p
+ AD=0.33115p PS=2.16u PD=1.635u
M$748 \$1747 Veval VSS VSS sg13_lv_nmos L=0.13u W=0.74u AS=0.33115p AD=0.2516p
+ PS=1.635u PD=2.16u
M$749 \$1678 \$1745 VSS VSS sg13_lv_nmos L=0.13u W=0.74u AS=0.2516p AD=0.2516p
+ PS=2.16u PD=2.16u
M$750 VSS \$1679 \$1748 VSS sg13_lv_nmos L=0.13u W=0.74u AS=0.2516p AD=0.33115p
+ PS=2.16u PD=1.635u
M$751 \$1748 \$1688 \$266 VSS sg13_lv_nmos L=0.13u W=0.74u AS=0.33115p
+ AD=0.33115p PS=1.635u PD=1.635u
M$752 \$266 \$1748 \$1749 VSS sg13_lv_nmos L=0.13u W=0.74u AS=0.33115p
+ AD=0.33115p PS=1.635u PD=1.635u
M$753 \$1749 \$1679 \$268 VSS sg13_lv_nmos L=0.13u W=0.74u AS=0.33115p
+ AD=0.33115p PS=1.635u PD=1.635u
M$754 \$268 \$1688 \$1679 VSS sg13_lv_nmos L=0.13u W=0.74u AS=0.33115p
+ AD=0.2516p PS=1.635u PD=2.16u
M$755 \$1677 \$1749 \$1750 VSS sg13_lv_nmos L=0.13u W=0.74u AS=0.2516p
+ AD=0.33115p PS=2.16u PD=1.635u
M$756 \$1750 Veval VSS VSS sg13_lv_nmos L=0.13u W=0.74u AS=0.33115p AD=0.2516p
+ PS=1.635u PD=2.16u
M$757 \$1679 \$1748 VSS VSS sg13_lv_nmos L=0.13u W=0.74u AS=0.2516p AD=0.2516p
+ PS=2.16u PD=2.16u
M$758 VSS \$1680 \$1751 VSS sg13_lv_nmos L=0.13u W=0.74u AS=0.2516p AD=0.33115p
+ PS=2.16u PD=1.635u
M$759 \$1751 \$1688 \$271 VSS sg13_lv_nmos L=0.13u W=0.74u AS=0.33115p
+ AD=0.33115p PS=1.635u PD=1.635u
M$760 \$271 \$1751 \$1752 VSS sg13_lv_nmos L=0.13u W=0.74u AS=0.33115p
+ AD=0.33115p PS=1.635u PD=1.635u
M$761 \$1752 \$1680 \$273 VSS sg13_lv_nmos L=0.13u W=0.74u AS=0.33115p
+ AD=0.33115p PS=1.635u PD=1.635u
M$762 \$273 \$1688 \$1680 VSS sg13_lv_nmos L=0.13u W=0.74u AS=0.33115p
+ AD=0.2516p PS=1.635u PD=2.16u
M$763 \$1677 \$1752 \$1753 VSS sg13_lv_nmos L=0.13u W=0.74u AS=0.2516p
+ AD=0.33115p PS=2.16u PD=1.635u
M$764 \$1753 Veval VSS VSS sg13_lv_nmos L=0.13u W=0.74u AS=0.33115p AD=0.2516p
+ PS=1.635u PD=2.16u
M$765 \$1680 \$1751 VSS VSS sg13_lv_nmos L=0.13u W=0.74u AS=0.2516p AD=0.2516p
+ PS=2.16u PD=2.16u
M$766 VSS \$1681 \$1754 VSS sg13_lv_nmos L=0.13u W=0.74u AS=0.2516p AD=0.33115p
+ PS=2.16u PD=1.635u
M$767 \$1754 \$1688 \$276 VSS sg13_lv_nmos L=0.13u W=0.74u AS=0.33115p
+ AD=0.33115p PS=1.635u PD=1.635u
M$768 \$276 \$1754 \$1755 VSS sg13_lv_nmos L=0.13u W=0.74u AS=0.33115p
+ AD=0.33115p PS=1.635u PD=1.635u
M$769 \$1755 \$1681 \$278 VSS sg13_lv_nmos L=0.13u W=0.74u AS=0.33115p
+ AD=0.33115p PS=1.635u PD=1.635u
M$770 \$278 \$1688 \$1681 VSS sg13_lv_nmos L=0.13u W=0.74u AS=0.33115p
+ AD=0.2516p PS=1.635u PD=2.16u
M$771 \$1677 \$1755 \$1756 VSS sg13_lv_nmos L=0.13u W=0.74u AS=0.2516p
+ AD=0.33115p PS=2.16u PD=1.635u
M$772 \$1756 Veval VSS VSS sg13_lv_nmos L=0.13u W=0.74u AS=0.33115p AD=0.2516p
+ PS=1.635u PD=2.16u
M$773 \$1681 \$1754 VSS VSS sg13_lv_nmos L=0.13u W=0.74u AS=0.2516p AD=0.2516p
+ PS=2.16u PD=2.16u
M$774 VSS \$1682 \$1757 VSS sg13_lv_nmos L=0.13u W=0.74u AS=0.2516p AD=0.33115p
+ PS=2.16u PD=1.635u
M$775 \$1757 \$1688 \$281 VSS sg13_lv_nmos L=0.13u W=0.74u AS=0.33115p
+ AD=0.33115p PS=1.635u PD=1.635u
M$776 \$281 \$1757 \$1758 VSS sg13_lv_nmos L=0.13u W=0.74u AS=0.33115p
+ AD=0.33115p PS=1.635u PD=1.635u
M$777 \$1758 \$1682 \$283 VSS sg13_lv_nmos L=0.13u W=0.74u AS=0.33115p
+ AD=0.33115p PS=1.635u PD=1.635u
M$778 \$283 \$1688 \$1682 VSS sg13_lv_nmos L=0.13u W=0.74u AS=0.33115p
+ AD=0.2516p PS=1.635u PD=2.16u
M$779 \$1677 \$1758 \$1759 VSS sg13_lv_nmos L=0.13u W=0.74u AS=0.2516p
+ AD=0.33115p PS=2.16u PD=1.635u
M$780 \$1759 Veval VSS VSS sg13_lv_nmos L=0.13u W=0.74u AS=0.33115p AD=0.2516p
+ PS=1.635u PD=2.16u
M$781 \$1682 \$1757 VSS VSS sg13_lv_nmos L=0.13u W=0.74u AS=0.2516p AD=0.2516p
+ PS=2.16u PD=2.16u
M$782 VSS \$1683 \$1760 VSS sg13_lv_nmos L=0.13u W=0.74u AS=0.2516p AD=0.33115p
+ PS=2.16u PD=1.635u
M$783 \$1760 \$1688 \$286 VSS sg13_lv_nmos L=0.13u W=0.74u AS=0.33115p
+ AD=0.33115p PS=1.635u PD=1.635u
M$784 \$286 \$1760 \$1761 VSS sg13_lv_nmos L=0.13u W=0.74u AS=0.33115p
+ AD=0.33115p PS=1.635u PD=1.635u
M$785 \$1761 \$1683 \$288 VSS sg13_lv_nmos L=0.13u W=0.74u AS=0.33115p
+ AD=0.33115p PS=1.635u PD=1.635u
M$786 \$288 \$1688 \$1683 VSS sg13_lv_nmos L=0.13u W=0.74u AS=0.33115p
+ AD=0.2516p PS=1.635u PD=2.16u
M$787 \$1677 \$1761 \$1762 VSS sg13_lv_nmos L=0.13u W=0.74u AS=0.2516p
+ AD=0.33115p PS=2.16u PD=1.635u
M$788 \$1762 Veval VSS VSS sg13_lv_nmos L=0.13u W=0.74u AS=0.33115p AD=0.2516p
+ PS=1.635u PD=2.16u
M$789 \$1683 \$1760 VSS VSS sg13_lv_nmos L=0.13u W=0.74u AS=0.2516p AD=0.2516p
+ PS=2.16u PD=2.16u
M$790 VSS \$1684 \$1763 VSS sg13_lv_nmos L=0.13u W=0.74u AS=0.2516p AD=0.33115p
+ PS=2.16u PD=1.635u
M$791 \$1763 \$1688 \$291 VSS sg13_lv_nmos L=0.13u W=0.74u AS=0.33115p
+ AD=0.33115p PS=1.635u PD=1.635u
M$792 \$291 \$1763 \$1764 VSS sg13_lv_nmos L=0.13u W=0.74u AS=0.33115p
+ AD=0.33115p PS=1.635u PD=1.635u
M$793 \$1764 \$1684 \$293 VSS sg13_lv_nmos L=0.13u W=0.74u AS=0.33115p
+ AD=0.33115p PS=1.635u PD=1.635u
M$794 \$293 \$1688 \$1684 VSS sg13_lv_nmos L=0.13u W=0.74u AS=0.33115p
+ AD=0.2516p PS=1.635u PD=2.16u
M$795 \$1677 \$1764 \$1765 VSS sg13_lv_nmos L=0.13u W=0.74u AS=0.2516p
+ AD=0.33115p PS=2.16u PD=1.635u
M$796 \$1765 Veval VSS VSS sg13_lv_nmos L=0.13u W=0.74u AS=0.33115p AD=0.2516p
+ PS=1.635u PD=2.16u
M$797 \$1684 \$1763 VSS VSS sg13_lv_nmos L=0.13u W=0.74u AS=0.2516p AD=0.2516p
+ PS=2.16u PD=2.16u
M$798 VSS Veval \$1697 VSS sg13_lv_nmos L=0.13u W=0.74u AS=0.2516p AD=0.2516p
+ PS=2.16u PD=2.16u
M$799 VSS \$1697 \$1663 VSS sg13_lv_nmos L=0.13u W=2.96u AS=1.0064p AD=1.0064p
+ PS=6.6u PD=6.6u
M$800 VSS \$1663 \$1685 VSS sg13_lv_nmos L=0.13u W=0.74u AS=0.2516p AD=0.2516p
+ PS=2.16u PD=2.16u
M$801 VSS \$1685 \$1664 VSS sg13_lv_nmos L=0.13u W=2.96u AS=1.0064p AD=1.0064p
+ PS=6.6u PD=6.6u
M$802 \$1473 \$1685 \$1698 VSS sg13_lv_nmos L=0.13u W=0.74u AS=0.2516p
+ AD=0.2516p PS=2.16u PD=2.16u
M$803 VSS \$1698 \$1699 VSS sg13_lv_nmos L=0.13u W=0.74u AS=0.2516p AD=0.2516p
+ PS=2.16u PD=2.16u
M$804 VSS \$1699 \$1700 VSS sg13_lv_nmos L=0.13u W=0.74u AS=0.2516p AD=0.2516p
+ PS=2.16u PD=2.16u
M$805 \$1698 \$1664 \$1701 VSS sg13_lv_nmos L=0.13u W=0.74u AS=0.2516p
+ AD=0.2516p PS=2.16u PD=2.16u
M$806 \$1701 \$1699 VSS VSS sg13_lv_nmos L=0.13u W=0.74u AS=0.2516p AD=0.2516p
+ PS=2.16u PD=2.16u
M$807 VSS \$1921 \$1702 VSS sg13_lv_nmos L=0.13u W=0.74u AS=0.2516p AD=0.1406p
+ PS=2.16u PD=1.12u
M$808 \$1702 \$1665 \$1703 VSS sg13_lv_nmos L=0.13u W=0.74u AS=0.1406p
+ AD=0.1406p PS=1.12u PD=1.12u
M$809 \$1703 CLK \$1704 VSS sg13_lv_nmos L=0.13u W=0.74u AS=0.1406p AD=0.1406p
+ PS=1.12u PD=1.12u
M$810 \$1704 \$1705 VSS VSS sg13_lv_nmos L=0.13u W=0.74u AS=0.1406p AD=0.2516p
+ PS=1.12u PD=2.16u
M$811 VSS \$1703 \$1705 VSS sg13_lv_nmos L=0.13u W=0.74u AS=0.2516p AD=0.1406p
+ PS=2.16u PD=1.12u
M$812 \$1705 CLK \$1706 VSS sg13_lv_nmos L=0.13u W=0.74u AS=0.1406p AD=0.1406p
+ PS=1.12u PD=1.12u
M$813 \$1706 \$1665 \$1707 VSS sg13_lv_nmos L=0.13u W=0.74u AS=0.1406p
+ AD=0.1406p PS=1.12u PD=1.12u
M$814 \$1707 \$1708 VSS VSS sg13_lv_nmos L=0.13u W=0.74u AS=0.1406p AD=0.2516p
+ PS=1.12u PD=2.16u
M$815 VSS \$1706 \$1708 VSS sg13_lv_nmos L=0.13u W=0.74u AS=0.2516p AD=0.2516p
+ PS=2.16u PD=2.16u
M$816 VSS \$1708 \$1709 VSS sg13_lv_nmos L=0.13u W=0.74u AS=0.2516p AD=0.2516p
+ PS=2.16u PD=2.16u
M$817 VSS CLK \$1665 VSS sg13_lv_nmos L=0.13u W=0.74u AS=0.2516p AD=0.2516p
+ PS=2.16u PD=2.16u
M$818 VSS \$100 \$1710 VSS sg13_lv_nmos L=0.13u W=0.74u AS=0.2516p AD=0.2516p
+ PS=2.16u PD=2.16u
M$819 \$1711 \$1709 VSS VSS sg13_lv_nmos L=0.13u W=0.74u AS=0.2516p AD=0.1406p
+ PS=2.16u PD=1.12u
M$820 VSS VSS \$1689 VSS sg13_lv_nmos L=0.13u W=0.74u AS=0.1406p AD=0.2516p
+ PS=1.12u PD=2.16u
M$821 \$1711 \$100 \$1781 VSS sg13_lv_nmos L=0.13u W=0.74u AS=0.2516p
+ AD=0.1406p PS=2.16u PD=1.12u
M$822 \$1781 \$1710 \$1689 VSS sg13_lv_nmos L=0.13u W=0.74u AS=0.1406p
+ AD=0.2516p PS=1.12u PD=2.16u
M$823 VSS \$1781 \$1712 VSS sg13_lv_nmos L=0.13u W=0.74u AS=0.2516p AD=0.2516p
+ PS=2.16u PD=2.16u
M$824 VSS \$1712 \$1713 VSS sg13_lv_nmos L=0.13u W=0.74u AS=0.2516p AD=0.1406p
+ PS=2.16u PD=1.12u
M$825 \$1713 \$1666 \$1714 VSS sg13_lv_nmos L=0.13u W=0.74u AS=0.1406p
+ AD=0.1406p PS=1.12u PD=1.12u
M$826 \$1714 CLK \$1715 VSS sg13_lv_nmos L=0.13u W=0.74u AS=0.1406p AD=0.1406p
+ PS=1.12u PD=1.12u
M$827 \$1715 \$1716 VSS VSS sg13_lv_nmos L=0.13u W=0.74u AS=0.1406p AD=0.2516p
+ PS=1.12u PD=2.16u
M$828 VSS \$1714 \$1716 VSS sg13_lv_nmos L=0.13u W=0.74u AS=0.2516p AD=0.1406p
+ PS=2.16u PD=1.12u
M$829 \$1716 CLK \$1717 VSS sg13_lv_nmos L=0.13u W=0.74u AS=0.1406p AD=0.1406p
+ PS=1.12u PD=1.12u
M$830 \$1717 \$1666 \$1718 VSS sg13_lv_nmos L=0.13u W=0.74u AS=0.1406p
+ AD=0.1406p PS=1.12u PD=1.12u
M$831 \$1718 \$1719 VSS VSS sg13_lv_nmos L=0.13u W=0.74u AS=0.1406p AD=0.2516p
+ PS=1.12u PD=2.16u
M$832 VSS \$1717 \$1719 VSS sg13_lv_nmos L=0.13u W=0.74u AS=0.2516p AD=0.2516p
+ PS=2.16u PD=2.16u
M$833 VSS \$1719 \$1410 VSS sg13_lv_nmos L=0.13u W=0.74u AS=0.2516p AD=0.2516p
+ PS=2.16u PD=2.16u
M$834 VSS CLK \$1666 VSS sg13_lv_nmos L=0.13u W=0.74u AS=0.2516p AD=0.2516p
+ PS=2.16u PD=2.16u
M$835 VSS IN \$1948 VSS sg13_lv_nmos L=0.13u W=0.74u AS=0.2516p AD=0.1406p
+ PS=2.16u PD=1.12u
M$836 \$1948 \$1937 \$1949 VSS sg13_lv_nmos L=0.13u W=0.74u AS=0.1406p
+ AD=0.1406p PS=1.12u PD=1.12u
M$837 \$1949 \$1945 \$1950 VSS sg13_lv_nmos L=0.13u W=0.74u AS=0.1406p
+ AD=0.1406p PS=1.12u PD=1.12u
M$838 \$1950 \$1951 VSS VSS sg13_lv_nmos L=0.13u W=0.74u AS=0.1406p AD=0.2516p
+ PS=1.12u PD=2.16u
M$839 VSS \$1949 \$1951 VSS sg13_lv_nmos L=0.13u W=0.74u AS=0.2516p AD=0.1406p
+ PS=2.16u PD=1.12u
M$840 \$1951 \$1945 \$1952 VSS sg13_lv_nmos L=0.13u W=0.74u AS=0.1406p
+ AD=0.1406p PS=1.12u PD=1.12u
M$841 \$1952 \$1937 \$1953 VSS sg13_lv_nmos L=0.13u W=0.74u AS=0.1406p
+ AD=0.1406p PS=1.12u PD=1.12u
M$842 \$1953 \$256 VSS VSS sg13_lv_nmos L=0.13u W=0.74u AS=0.1406p AD=0.2516p
+ PS=1.12u PD=2.16u
M$843 VSS \$1952 \$256 VSS sg13_lv_nmos L=0.13u W=0.74u AS=0.2516p AD=0.2516p
+ PS=2.16u PD=2.16u
M$844 VSS \$256 \$258 VSS sg13_lv_nmos L=0.13u W=0.74u AS=0.2516p AD=0.2516p
+ PS=2.16u PD=2.16u
M$845 \$1902 \$1643 \$1903 VSS sg13_lv_nmos L=0.13u W=0.74u AS=0.2516p
+ AD=0.33115p PS=2.16u PD=1.635u
M$846 \$1903 EN_DEC VSS VSS sg13_lv_nmos L=0.13u W=0.74u AS=0.33115p AD=0.2516p
+ PS=1.635u PD=2.16u
M$847 VSS \$1945 \$1937 VSS sg13_lv_nmos L=0.13u W=0.74u AS=0.2516p AD=0.2516p
+ PS=2.16u PD=2.16u
M$848 VSS \$1902 \$1688 VSS sg13_lv_nmos L=0.13u W=0.74u AS=0.2516p AD=0.2516p
+ PS=2.16u PD=2.16u
M$849 VSS \$258 \$1954 VSS sg13_lv_nmos L=0.13u W=0.74u AS=0.2516p AD=0.1406p
+ PS=2.16u PD=1.12u
M$850 \$1954 \$1938 \$1955 VSS sg13_lv_nmos L=0.13u W=0.74u AS=0.1406p
+ AD=0.1406p PS=1.12u PD=1.12u
M$851 \$1955 \$1945 \$1956 VSS sg13_lv_nmos L=0.13u W=0.74u AS=0.1406p
+ AD=0.1406p PS=1.12u PD=1.12u
M$852 \$1956 \$1957 VSS VSS sg13_lv_nmos L=0.13u W=0.74u AS=0.1406p AD=0.2516p
+ PS=1.12u PD=2.16u
M$853 VSS \$1955 \$1957 VSS sg13_lv_nmos L=0.13u W=0.74u AS=0.2516p AD=0.1406p
+ PS=2.16u PD=1.12u
M$854 \$1957 \$1945 \$1958 VSS sg13_lv_nmos L=0.13u W=0.74u AS=0.1406p
+ AD=0.1406p PS=1.12u PD=1.12u
M$855 \$1958 \$1938 \$1959 VSS sg13_lv_nmos L=0.13u W=0.74u AS=0.1406p
+ AD=0.1406p PS=1.12u PD=1.12u
M$856 \$1959 \$261 VSS VSS sg13_lv_nmos L=0.13u W=0.74u AS=0.1406p AD=0.2516p
+ PS=1.12u PD=2.16u
M$857 VSS \$1958 \$261 VSS sg13_lv_nmos L=0.13u W=0.74u AS=0.2516p AD=0.2516p
+ PS=2.16u PD=2.16u
M$858 VSS \$261 \$263 VSS sg13_lv_nmos L=0.13u W=0.74u AS=0.2516p AD=0.2516p
+ PS=2.16u PD=2.16u
M$859 VSS \$1945 \$1938 VSS sg13_lv_nmos L=0.13u W=0.74u AS=0.2516p AD=0.2516p
+ PS=2.16u PD=2.16u
M$860 VSS \$263 \$1960 VSS sg13_lv_nmos L=0.13u W=0.74u AS=0.2516p AD=0.1406p
+ PS=2.16u PD=1.12u
M$861 \$1960 \$1939 \$1961 VSS sg13_lv_nmos L=0.13u W=0.74u AS=0.1406p
+ AD=0.1406p PS=1.12u PD=1.12u
M$862 \$1961 \$1945 \$1962 VSS sg13_lv_nmos L=0.13u W=0.74u AS=0.1406p
+ AD=0.1406p PS=1.12u PD=1.12u
M$863 \$1962 \$1963 VSS VSS sg13_lv_nmos L=0.13u W=0.74u AS=0.1406p AD=0.2516p
+ PS=1.12u PD=2.16u
M$864 VSS \$1961 \$1963 VSS sg13_lv_nmos L=0.13u W=0.74u AS=0.2516p AD=0.1406p
+ PS=2.16u PD=1.12u
M$865 \$1963 \$1945 \$1964 VSS sg13_lv_nmos L=0.13u W=0.74u AS=0.1406p
+ AD=0.1406p PS=1.12u PD=1.12u
M$866 \$1964 \$1939 \$1965 VSS sg13_lv_nmos L=0.13u W=0.74u AS=0.1406p
+ AD=0.1406p PS=1.12u PD=1.12u
M$867 \$1965 \$266 VSS VSS sg13_lv_nmos L=0.13u W=0.74u AS=0.1406p AD=0.2516p
+ PS=1.12u PD=2.16u
M$868 VSS \$1964 \$266 VSS sg13_lv_nmos L=0.13u W=0.74u AS=0.2516p AD=0.2516p
+ PS=2.16u PD=2.16u
M$869 VSS \$266 \$268 VSS sg13_lv_nmos L=0.13u W=0.74u AS=0.2516p AD=0.2516p
+ PS=2.16u PD=2.16u
M$870 VSS \$1945 \$1939 VSS sg13_lv_nmos L=0.13u W=0.74u AS=0.2516p AD=0.2516p
+ PS=2.16u PD=2.16u
M$871 VSS \$268 \$1966 VSS sg13_lv_nmos L=0.13u W=0.74u AS=0.2516p AD=0.1406p
+ PS=2.16u PD=1.12u
M$872 \$1966 \$1940 \$1967 VSS sg13_lv_nmos L=0.13u W=0.74u AS=0.1406p
+ AD=0.1406p PS=1.12u PD=1.12u
M$873 \$1967 \$1945 \$1968 VSS sg13_lv_nmos L=0.13u W=0.74u AS=0.1406p
+ AD=0.1406p PS=1.12u PD=1.12u
M$874 \$1968 \$1969 VSS VSS sg13_lv_nmos L=0.13u W=0.74u AS=0.1406p AD=0.2516p
+ PS=1.12u PD=2.16u
M$875 VSS \$1967 \$1969 VSS sg13_lv_nmos L=0.13u W=0.74u AS=0.2516p AD=0.1406p
+ PS=2.16u PD=1.12u
M$876 \$1969 \$1945 \$1970 VSS sg13_lv_nmos L=0.13u W=0.74u AS=0.1406p
+ AD=0.1406p PS=1.12u PD=1.12u
M$877 \$1970 \$1940 \$1971 VSS sg13_lv_nmos L=0.13u W=0.74u AS=0.1406p
+ AD=0.1406p PS=1.12u PD=1.12u
M$878 \$1971 \$271 VSS VSS sg13_lv_nmos L=0.13u W=0.74u AS=0.1406p AD=0.2516p
+ PS=1.12u PD=2.16u
M$879 VSS \$1970 \$271 VSS sg13_lv_nmos L=0.13u W=0.74u AS=0.2516p AD=0.2516p
+ PS=2.16u PD=2.16u
M$880 VSS \$271 \$273 VSS sg13_lv_nmos L=0.13u W=0.74u AS=0.2516p AD=0.2516p
+ PS=2.16u PD=2.16u
M$881 VSS \$1945 \$1940 VSS sg13_lv_nmos L=0.13u W=0.74u AS=0.2516p AD=0.2516p
+ PS=2.16u PD=2.16u
M$882 VSS \$273 \$1972 VSS sg13_lv_nmos L=0.13u W=0.74u AS=0.2516p AD=0.1406p
+ PS=2.16u PD=1.12u
M$883 \$1972 \$1941 \$1973 VSS sg13_lv_nmos L=0.13u W=0.74u AS=0.1406p
+ AD=0.1406p PS=1.12u PD=1.12u
M$884 \$1973 \$1945 \$1974 VSS sg13_lv_nmos L=0.13u W=0.74u AS=0.1406p
+ AD=0.1406p PS=1.12u PD=1.12u
M$885 \$1974 \$1975 VSS VSS sg13_lv_nmos L=0.13u W=0.74u AS=0.1406p AD=0.2516p
+ PS=1.12u PD=2.16u
M$886 VSS \$1973 \$1975 VSS sg13_lv_nmos L=0.13u W=0.74u AS=0.2516p AD=0.1406p
+ PS=2.16u PD=1.12u
M$887 \$1975 \$1945 \$1976 VSS sg13_lv_nmos L=0.13u W=0.74u AS=0.1406p
+ AD=0.1406p PS=1.12u PD=1.12u
M$888 \$1976 \$1941 \$1977 VSS sg13_lv_nmos L=0.13u W=0.74u AS=0.1406p
+ AD=0.1406p PS=1.12u PD=1.12u
M$889 \$1977 \$276 VSS VSS sg13_lv_nmos L=0.13u W=0.74u AS=0.1406p AD=0.2516p
+ PS=1.12u PD=2.16u
M$890 VSS \$1976 \$276 VSS sg13_lv_nmos L=0.13u W=0.74u AS=0.2516p AD=0.2516p
+ PS=2.16u PD=2.16u
M$891 VSS \$276 \$278 VSS sg13_lv_nmos L=0.13u W=0.74u AS=0.2516p AD=0.2516p
+ PS=2.16u PD=2.16u
M$892 VSS \$1945 \$1941 VSS sg13_lv_nmos L=0.13u W=0.74u AS=0.2516p AD=0.2516p
+ PS=2.16u PD=2.16u
M$893 VSS \$278 \$1978 VSS sg13_lv_nmos L=0.13u W=0.74u AS=0.2516p AD=0.1406p
+ PS=2.16u PD=1.12u
M$894 \$1978 \$1942 \$1979 VSS sg13_lv_nmos L=0.13u W=0.74u AS=0.1406p
+ AD=0.1406p PS=1.12u PD=1.12u
M$895 \$1979 \$1945 \$1980 VSS sg13_lv_nmos L=0.13u W=0.74u AS=0.1406p
+ AD=0.1406p PS=1.12u PD=1.12u
M$896 \$1980 \$1981 VSS VSS sg13_lv_nmos L=0.13u W=0.74u AS=0.1406p AD=0.2516p
+ PS=1.12u PD=2.16u
M$897 VSS \$1979 \$1981 VSS sg13_lv_nmos L=0.13u W=0.74u AS=0.2516p AD=0.1406p
+ PS=2.16u PD=1.12u
M$898 \$1981 \$1945 \$1982 VSS sg13_lv_nmos L=0.13u W=0.74u AS=0.1406p
+ AD=0.1406p PS=1.12u PD=1.12u
M$899 \$1982 \$1942 \$1983 VSS sg13_lv_nmos L=0.13u W=0.74u AS=0.1406p
+ AD=0.1406p PS=1.12u PD=1.12u
M$900 \$1983 \$281 VSS VSS sg13_lv_nmos L=0.13u W=0.74u AS=0.1406p AD=0.2516p
+ PS=1.12u PD=2.16u
M$901 VSS \$1982 \$281 VSS sg13_lv_nmos L=0.13u W=0.74u AS=0.2516p AD=0.2516p
+ PS=2.16u PD=2.16u
M$902 VSS \$281 \$283 VSS sg13_lv_nmos L=0.13u W=0.74u AS=0.2516p AD=0.2516p
+ PS=2.16u PD=2.16u
M$903 VSS \$1945 \$1942 VSS sg13_lv_nmos L=0.13u W=0.74u AS=0.2516p AD=0.2516p
+ PS=2.16u PD=2.16u
M$904 VSS \$283 \$1984 VSS sg13_lv_nmos L=0.13u W=0.74u AS=0.2516p AD=0.1406p
+ PS=2.16u PD=1.12u
M$905 \$1984 \$1943 \$1985 VSS sg13_lv_nmos L=0.13u W=0.74u AS=0.1406p
+ AD=0.1406p PS=1.12u PD=1.12u
M$906 \$1985 \$1945 \$1986 VSS sg13_lv_nmos L=0.13u W=0.74u AS=0.1406p
+ AD=0.1406p PS=1.12u PD=1.12u
M$907 \$1986 \$1987 VSS VSS sg13_lv_nmos L=0.13u W=0.74u AS=0.1406p AD=0.2516p
+ PS=1.12u PD=2.16u
M$908 VSS \$1985 \$1987 VSS sg13_lv_nmos L=0.13u W=0.74u AS=0.2516p AD=0.1406p
+ PS=2.16u PD=1.12u
M$909 \$1987 \$1945 \$1988 VSS sg13_lv_nmos L=0.13u W=0.74u AS=0.1406p
+ AD=0.1406p PS=1.12u PD=1.12u
M$910 \$1988 \$1943 \$1989 VSS sg13_lv_nmos L=0.13u W=0.74u AS=0.1406p
+ AD=0.1406p PS=1.12u PD=1.12u
M$911 \$1989 \$286 VSS VSS sg13_lv_nmos L=0.13u W=0.74u AS=0.1406p AD=0.2516p
+ PS=1.12u PD=2.16u
M$912 VSS \$1988 \$286 VSS sg13_lv_nmos L=0.13u W=0.74u AS=0.2516p AD=0.2516p
+ PS=2.16u PD=2.16u
M$913 VSS \$286 \$288 VSS sg13_lv_nmos L=0.13u W=0.74u AS=0.2516p AD=0.2516p
+ PS=2.16u PD=2.16u
M$914 VSS \$1945 \$1943 VSS sg13_lv_nmos L=0.13u W=0.74u AS=0.2516p AD=0.2516p
+ PS=2.16u PD=2.16u
M$915 VSS \$288 \$1990 VSS sg13_lv_nmos L=0.13u W=0.74u AS=0.2516p AD=0.1406p
+ PS=2.16u PD=1.12u
M$916 \$1990 \$1944 \$1991 VSS sg13_lv_nmos L=0.13u W=0.74u AS=0.1406p
+ AD=0.1406p PS=1.12u PD=1.12u
M$917 \$1991 \$1945 \$1992 VSS sg13_lv_nmos L=0.13u W=0.74u AS=0.1406p
+ AD=0.1406p PS=1.12u PD=1.12u
M$918 \$1992 \$1993 VSS VSS sg13_lv_nmos L=0.13u W=0.74u AS=0.1406p AD=0.2516p
+ PS=1.12u PD=2.16u
M$919 VSS \$1991 \$1993 VSS sg13_lv_nmos L=0.13u W=0.74u AS=0.2516p AD=0.1406p
+ PS=2.16u PD=1.12u
M$920 \$1993 \$1945 \$1994 VSS sg13_lv_nmos L=0.13u W=0.74u AS=0.1406p
+ AD=0.1406p PS=1.12u PD=1.12u
M$921 \$1994 \$1944 \$1995 VSS sg13_lv_nmos L=0.13u W=0.74u AS=0.1406p
+ AD=0.1406p PS=1.12u PD=1.12u
M$922 \$1995 \$291 VSS VSS sg13_lv_nmos L=0.13u W=0.74u AS=0.1406p AD=0.2516p
+ PS=1.12u PD=2.16u
M$923 VSS \$1994 \$291 VSS sg13_lv_nmos L=0.13u W=0.74u AS=0.2516p AD=0.2516p
+ PS=2.16u PD=2.16u
M$924 VSS \$291 \$293 VSS sg13_lv_nmos L=0.13u W=0.74u AS=0.2516p AD=0.2516p
+ PS=2.16u PD=2.16u
M$925 VSS \$1945 \$1944 VSS sg13_lv_nmos L=0.13u W=0.74u AS=0.2516p AD=0.2516p
+ PS=2.16u PD=2.16u
M$926 VSS Veval \$1918 VSS sg13_lv_nmos L=0.13u W=0.74u AS=0.2516p AD=0.2516p
+ PS=2.16u PD=2.16u
M$927 VSS \$1918 \$1905 VSS sg13_lv_nmos L=0.13u W=2.96u AS=1.0064p AD=1.0064p
+ PS=6.6u PD=6.6u
M$928 VSS \$1905 \$1915 VSS sg13_lv_nmos L=0.13u W=0.74u AS=0.2516p AD=0.2516p
+ PS=2.16u PD=2.16u
M$929 VSS \$1915 \$1906 VSS sg13_lv_nmos L=0.13u W=2.96u AS=1.0064p AD=1.0064p
+ PS=6.6u PD=6.6u
M$930 \$1677 \$1915 \$1919 VSS sg13_lv_nmos L=0.13u W=0.74u AS=0.2516p
+ AD=0.2516p PS=2.16u PD=2.16u
M$931 VSS \$1919 \$1920 VSS sg13_lv_nmos L=0.13u W=0.74u AS=0.2516p AD=0.2516p
+ PS=2.16u PD=2.16u
M$932 VSS \$1920 \$1921 VSS sg13_lv_nmos L=0.13u W=0.74u AS=0.2516p AD=0.2516p
+ PS=2.16u PD=2.16u
M$933 \$1919 \$1906 \$1922 VSS sg13_lv_nmos L=0.13u W=0.74u AS=0.2516p
+ AD=0.2516p PS=2.16u PD=2.16u
M$934 \$1922 \$1920 VSS VSS sg13_lv_nmos L=0.13u W=0.74u AS=0.2516p AD=0.2516p
+ PS=2.16u PD=2.16u
M$935 VSS EN \$2173 VSS sg13_lv_nmos L=0.13u W=0.74u AS=0.2516p AD=0.2516p
+ PS=2.16u PD=2.16u
M$936 VSS \$2173 \$2370 VSS sg13_lv_nmos L=0.13u W=0.74u AS=0.2516p AD=0.33115p
+ PS=2.16u PD=1.635u
M$937 \$2370 \$2174 \$2371 VSS sg13_lv_nmos L=0.13u W=0.74u AS=0.33115p
+ AD=0.2516p PS=1.635u PD=2.16u
M$938 VSS \$2371 \$2372 VSS sg13_lv_nmos L=0.13u W=0.74u AS=0.2516p AD=0.33115p
+ PS=2.16u PD=1.635u
M$939 \$2372 CLK \$2373 VSS sg13_lv_nmos L=0.13u W=0.74u AS=0.33115p AD=0.2516p
+ PS=1.635u PD=2.16u
M$940 VSS \$2373 \$1945 VSS sg13_lv_nmos L=0.13u W=0.74u AS=0.2516p AD=0.2516p
+ PS=2.16u PD=2.16u
M$941 VSS \$2182 \$2176 VSS sg13_lv_nmos L=0.13u W=0.74u AS=0.2516p AD=0.1406p
+ PS=2.16u PD=1.12u
M$942 \$2176 \$2175 \$2177 VSS sg13_lv_nmos L=0.13u W=0.74u AS=0.1406p
+ AD=0.1406p PS=1.12u PD=1.12u
M$943 \$2177 \$1945 \$2178 VSS sg13_lv_nmos L=0.13u W=0.74u AS=0.1406p
+ AD=0.1406p PS=1.12u PD=1.12u
M$944 \$2178 \$2179 VSS VSS sg13_lv_nmos L=0.13u W=0.74u AS=0.1406p AD=0.2516p
+ PS=1.12u PD=2.16u
M$945 VSS \$2177 \$2179 VSS sg13_lv_nmos L=0.13u W=0.74u AS=0.2516p AD=0.1406p
+ PS=2.16u PD=1.12u
M$946 \$2179 \$1945 \$2180 VSS sg13_lv_nmos L=0.13u W=0.74u AS=0.1406p
+ AD=0.1406p PS=1.12u PD=1.12u
M$947 \$2180 \$2175 \$2181 VSS sg13_lv_nmos L=0.13u W=0.74u AS=0.1406p
+ AD=0.1406p PS=1.12u PD=1.12u
M$948 \$2181 \$2182 VSS VSS sg13_lv_nmos L=0.13u W=0.74u AS=0.1406p AD=0.2516p
+ PS=1.12u PD=2.16u
M$949 VSS \$2180 \$2182 VSS sg13_lv_nmos L=0.13u W=0.74u AS=0.2516p AD=0.2516p
+ PS=2.16u PD=2.16u
M$950 VSS \$2182 \$2192 VSS sg13_lv_nmos L=0.13u W=0.74u AS=0.2516p AD=0.2516p
+ PS=2.16u PD=2.16u
M$951 VSS \$1945 \$2175 VSS sg13_lv_nmos L=0.13u W=0.74u AS=0.2516p AD=0.2516p
+ PS=2.16u PD=2.16u
M$952 VSS \$2429 \$2184 VSS sg13_lv_nmos L=0.13u W=0.74u AS=0.2516p AD=0.1406p
+ PS=2.16u PD=1.12u
M$953 \$2184 \$2183 \$2185 VSS sg13_lv_nmos L=0.13u W=0.74u AS=0.1406p
+ AD=0.1406p PS=1.12u PD=1.12u
M$954 \$2185 \$2192 \$2186 VSS sg13_lv_nmos L=0.13u W=0.74u AS=0.1406p
+ AD=0.1406p PS=1.12u PD=1.12u
M$955 \$2186 \$2187 VSS VSS sg13_lv_nmos L=0.13u W=0.74u AS=0.1406p AD=0.2516p
+ PS=1.12u PD=2.16u
M$956 VSS \$2185 \$2187 VSS sg13_lv_nmos L=0.13u W=0.74u AS=0.2516p AD=0.1406p
+ PS=2.16u PD=1.12u
M$957 \$2187 \$2192 \$2188 VSS sg13_lv_nmos L=0.13u W=0.74u AS=0.1406p
+ AD=0.1406p PS=1.12u PD=1.12u
M$958 \$2188 \$2183 \$2189 VSS sg13_lv_nmos L=0.13u W=0.74u AS=0.1406p
+ AD=0.1406p PS=1.12u PD=1.12u
M$959 \$2189 \$2429 VSS VSS sg13_lv_nmos L=0.13u W=0.74u AS=0.1406p AD=0.2516p
+ PS=1.12u PD=2.16u
M$960 VSS \$2188 \$2429 VSS sg13_lv_nmos L=0.13u W=0.74u AS=0.2516p AD=0.2516p
+ PS=2.16u PD=2.16u
M$961 VSS \$2429 \$2191 VSS sg13_lv_nmos L=0.13u W=0.74u AS=0.2516p AD=0.2516p
+ PS=2.16u PD=2.16u
M$962 VSS \$2192 \$2183 VSS sg13_lv_nmos L=0.13u W=0.74u AS=0.2516p AD=0.2516p
+ PS=2.16u PD=2.16u
M$963 VSS \$2380 \$2374 VSS sg13_lv_nmos L=0.13u W=0.74u AS=0.2516p AD=0.1406p
+ PS=2.16u PD=1.12u
M$964 \$2374 \$2190 \$2375 VSS sg13_lv_nmos L=0.13u W=0.74u AS=0.1406p
+ AD=0.1406p PS=1.12u PD=1.12u
M$965 \$2375 \$2191 \$2376 VSS sg13_lv_nmos L=0.13u W=0.74u AS=0.1406p
+ AD=0.1406p PS=1.12u PD=1.12u
M$966 \$2376 \$2377 VSS VSS sg13_lv_nmos L=0.13u W=0.74u AS=0.1406p AD=0.2516p
+ PS=1.12u PD=2.16u
M$967 VSS \$2375 \$2377 VSS sg13_lv_nmos L=0.13u W=0.74u AS=0.2516p AD=0.1406p
+ PS=2.16u PD=1.12u
M$968 \$2377 \$2191 \$2378 VSS sg13_lv_nmos L=0.13u W=0.74u AS=0.1406p
+ AD=0.1406p PS=1.12u PD=1.12u
M$969 \$2378 \$2190 \$2379 VSS sg13_lv_nmos L=0.13u W=0.74u AS=0.1406p
+ AD=0.1406p PS=1.12u PD=1.12u
M$970 \$2379 \$2380 VSS VSS sg13_lv_nmos L=0.13u W=0.74u AS=0.1406p AD=0.2516p
+ PS=1.12u PD=2.16u
M$971 VSS \$2378 \$2380 VSS sg13_lv_nmos L=0.13u W=0.74u AS=0.2516p AD=0.2516p
+ PS=2.16u PD=2.16u
M$972 VSS \$2380 \$2381 VSS sg13_lv_nmos L=0.13u W=0.74u AS=0.2516p AD=0.2516p
+ PS=2.16u PD=2.16u
M$973 VSS \$2191 \$2190 VSS sg13_lv_nmos L=0.13u W=0.74u AS=0.2516p AD=0.2516p
+ PS=2.16u PD=2.16u
M$974 \$2382 \$2381 \$2383 VSS sg13_lv_nmos L=0.13u W=0.74u AS=0.2516p
+ AD=0.1406p PS=2.16u PD=1.12u
M$975 \$2383 \$2191 \$2384 VSS sg13_lv_nmos L=0.13u W=0.74u AS=0.1406p
+ AD=0.1406p PS=1.12u PD=1.12u
M$976 \$2384 \$2192 VSS VSS sg13_lv_nmos L=0.13u W=0.74u AS=0.1406p AD=0.2516p
+ PS=1.12u PD=2.16u
M$977 VSS \$2382 \$2174 VSS sg13_lv_nmos L=0.13u W=0.74u AS=0.2516p AD=0.2516p
+ PS=2.16u PD=2.16u
M$978 VSS EN \$100 VSS sg13_lv_nmos L=0.13u W=0.74u AS=0.2516p AD=0.2516p
+ PS=2.16u PD=2.16u
M$979 \$12 \$10 VDD VDD sg13_lv_pmos L=0.13u W=1.12u AS=0.3808p AD=0.3808p
+ PS=2.92u PD=2.92u
M$980 VDD Veval \$8 VDD sg13_lv_pmos L=0.13u W=1.12u AS=0.3808p AD=0.3808p
+ PS=2.92u PD=2.92u
M$981 VDD \$8 \$3 VDD sg13_lv_pmos L=0.13u W=4.48u AS=1.5232p AD=1.5232p
+ PS=9.64u PD=9.64u
M$982 VDD \$3 \$5 VDD sg13_lv_pmos L=0.13u W=1.12u AS=0.3808p AD=0.3808p
+ PS=2.92u PD=2.92u
M$983 VDD \$5 \$4 VDD sg13_lv_pmos L=0.13u W=4.48u AS=1.5232p AD=1.5232p
+ PS=9.64u PD=9.64u
M$984 \$239 \$4 \$9 VDD sg13_lv_pmos L=0.13u W=1.12u AS=0.3808p AD=0.3808p
+ PS=2.92u PD=2.92u
M$985 VDD \$9 \$10 VDD sg13_lv_pmos L=0.13u W=1.12u AS=0.3808p AD=0.3808p
+ PS=2.92u PD=2.92u
M$986 VDD \$10 \$11 VDD sg13_lv_pmos L=0.13u W=1.12u AS=0.3808p AD=0.3808p
+ PS=2.92u PD=2.92u
M$987 \$9 \$5 \$12 VDD sg13_lv_pmos L=0.13u W=1.12u AS=0.3808p AD=0.3808p
+ PS=2.92u PD=2.92u
M$988 VDD Veval \$38 VDD sg13_lv_pmos L=0.13u W=1.12u AS=0.3808p AD=0.3808p
+ PS=2.92u PD=2.92u
M$989 VDD \$38 \$30 VDD sg13_lv_pmos L=0.13u W=4.48u AS=1.5232p AD=1.5232p
+ PS=9.64u PD=9.64u
M$990 VDD \$30 \$35 VDD sg13_lv_pmos L=0.13u W=1.12u AS=0.3808p AD=0.3808p
+ PS=2.92u PD=2.92u
M$991 VDD \$35 \$31 VDD sg13_lv_pmos L=0.13u W=4.48u AS=1.5232p AD=1.5232p
+ PS=9.64u PD=9.64u
M$992 \$443 \$31 \$39 VDD sg13_lv_pmos L=0.13u W=1.12u AS=0.3808p AD=0.3808p
+ PS=2.92u PD=2.92u
M$993 VDD \$39 \$40 VDD sg13_lv_pmos L=0.13u W=1.12u AS=0.3808p AD=0.3808p
+ PS=2.92u PD=2.92u
M$994 VDD \$40 \$41 VDD sg13_lv_pmos L=0.13u W=1.12u AS=0.3808p AD=0.3808p
+ PS=2.92u PD=2.92u
M$995 \$39 \$35 \$42 VDD sg13_lv_pmos L=0.13u W=1.12u AS=0.3808p AD=0.3808p
+ PS=2.92u PD=2.92u
M$996 \$42 \$40 VDD VDD sg13_lv_pmos L=0.13u W=1.12u AS=0.3808p AD=0.3808p
+ PS=2.92u PD=2.92u
M$997 VDD \$11 \$52 VDD sg13_lv_pmos L=0.13u W=1.12u AS=0.3808p AD=0.2128p
+ PS=2.92u PD=1.5u
M$998 \$52 CLK \$53 VDD sg13_lv_pmos L=0.13u W=1.12u AS=0.2128p AD=0.2128p
+ PS=1.5u PD=1.5u
M$999 \$53 \$32 \$54 VDD sg13_lv_pmos L=0.13u W=1.12u AS=0.2128p AD=0.2128p
+ PS=1.5u PD=1.5u
M$1000 \$54 \$55 VDD VDD sg13_lv_pmos L=0.13u W=1.12u AS=0.2128p AD=0.3808p
+ PS=1.5u PD=2.92u
M$1001 VDD \$53 \$55 VDD sg13_lv_pmos L=0.13u W=1.12u AS=0.3808p AD=0.2128p
+ PS=2.92u PD=1.5u
M$1002 \$55 \$32 \$56 VDD sg13_lv_pmos L=0.13u W=1.12u AS=0.2128p AD=0.2128p
+ PS=1.5u PD=1.5u
M$1003 \$56 CLK \$57 VDD sg13_lv_pmos L=0.13u W=1.12u AS=0.2128p AD=0.2128p
+ PS=1.5u PD=1.5u
M$1004 \$57 \$58 VDD VDD sg13_lv_pmos L=0.13u W=1.12u AS=0.2128p AD=0.3808p
+ PS=1.5u PD=2.92u
M$1005 VDD \$56 \$58 VDD sg13_lv_pmos L=0.13u W=1.12u AS=0.3808p AD=0.3808p
+ PS=2.92u PD=2.92u
M$1006 VDD \$58 \$59 VDD sg13_lv_pmos L=0.13u W=1.12u AS=0.3808p AD=0.3808p
+ PS=2.92u PD=2.92u
M$1007 VDD CLK \$32 VDD sg13_lv_pmos L=0.13u W=1.12u AS=0.3808p AD=0.3808p
+ PS=2.92u PD=2.92u
M$1008 VDD \$100 \$68 VDD sg13_lv_pmos L=0.13u W=1.12u AS=0.3808p AD=0.3808p
+ PS=2.92u PD=2.92u
M$1009 \$108 \$59 VDD VDD sg13_lv_pmos L=0.13u W=1.12u AS=0.3808p AD=0.2128p
+ PS=2.92u PD=1.5u
M$1010 VDD \$33 \$109 VDD sg13_lv_pmos L=0.13u W=1.12u AS=0.2128p AD=0.2128p
+ PS=1.5u PD=1.5u
M$1011 \$109 \$100 \$70 VDD sg13_lv_pmos L=0.13u W=1.12u AS=0.2128p AD=0.2128p
+ PS=1.5u PD=1.5u
M$1012 \$70 \$68 \$108 VDD sg13_lv_pmos L=0.13u W=1.12u AS=0.2128p AD=0.3808p
+ PS=1.5u PD=2.92u
M$1013 VDD \$70 \$71 VDD sg13_lv_pmos L=0.13u W=1.12u AS=0.3808p AD=0.3808p
+ PS=2.92u PD=2.92u
M$1014 VDD \$71 \$60 VDD sg13_lv_pmos L=0.13u W=1.12u AS=0.3808p AD=0.2128p
+ PS=2.92u PD=1.5u
M$1015 \$60 CLK \$61 VDD sg13_lv_pmos L=0.13u W=1.12u AS=0.2128p AD=0.2128p
+ PS=1.5u PD=1.5u
M$1016 \$61 \$34 \$62 VDD sg13_lv_pmos L=0.13u W=1.12u AS=0.2128p AD=0.2128p
+ PS=1.5u PD=1.5u
M$1017 \$62 \$63 VDD VDD sg13_lv_pmos L=0.13u W=1.12u AS=0.2128p AD=0.3808p
+ PS=1.5u PD=2.92u
M$1018 VDD \$61 \$63 VDD sg13_lv_pmos L=0.13u W=1.12u AS=0.3808p AD=0.2128p
+ PS=2.92u PD=1.5u
M$1019 \$63 \$34 \$64 VDD sg13_lv_pmos L=0.13u W=1.12u AS=0.2128p AD=0.2128p
+ PS=1.5u PD=1.5u
M$1020 \$64 CLK \$65 VDD sg13_lv_pmos L=0.13u W=1.12u AS=0.2128p AD=0.2128p
+ PS=1.5u PD=1.5u
M$1021 \$65 \$66 VDD VDD sg13_lv_pmos L=0.13u W=1.12u AS=0.2128p AD=0.3808p
+ PS=1.5u PD=2.92u
M$1022 VDD \$64 \$66 VDD sg13_lv_pmos L=0.13u W=1.12u AS=0.3808p AD=0.3808p
+ PS=2.92u PD=2.92u
M$1023 VDD \$66 OUT_FIN VDD sg13_lv_pmos L=0.13u W=1.12u AS=0.3808p AD=0.3808p
+ PS=2.92u PD=2.92u
M$1024 VDD CLK \$34 VDD sg13_lv_pmos L=0.13u W=1.12u AS=0.3808p AD=0.3808p
+ PS=2.92u PD=2.92u
M$1025 VDD Veval \$226 VDD sg13_lv_pmos L=0.13u W=1.12u AS=0.3808p AD=0.3808p
+ PS=2.92u PD=2.92u
M$1026 VDD \$226 \$159 VDD sg13_lv_pmos L=0.13u W=4.48u AS=1.5232p AD=1.5232p
+ PS=9.64u PD=9.64u
M$1027 VDD \$159 \$193 VDD sg13_lv_pmos L=0.13u W=1.12u AS=0.3808p AD=0.3808p
+ PS=2.92u PD=2.92u
M$1028 VDD \$193 \$160 VDD sg13_lv_pmos L=0.13u W=4.48u AS=1.5232p AD=1.5232p
+ PS=9.64u PD=9.64u
M$1029 \$647 \$160 \$227 VDD sg13_lv_pmos L=0.13u W=1.12u AS=0.3808p AD=0.3808p
+ PS=2.92u PD=2.92u
M$1030 VDD \$227 \$228 VDD sg13_lv_pmos L=0.13u W=1.12u AS=0.3808p AD=0.3808p
+ PS=2.92u PD=2.92u
M$1031 VDD \$228 \$229 VDD sg13_lv_pmos L=0.13u W=1.12u AS=0.3808p AD=0.3808p
+ PS=2.92u PD=2.92u
M$1032 \$227 \$193 \$230 VDD sg13_lv_pmos L=0.13u W=1.12u AS=0.3808p AD=0.3808p
+ PS=2.92u PD=2.92u
M$1033 \$230 \$228 VDD VDD sg13_lv_pmos L=0.13u W=1.12u AS=0.3808p AD=0.3808p
+ PS=2.92u PD=2.92u
M$1034 VDD \$41 \$144 VDD sg13_lv_pmos L=0.13u W=1.12u AS=0.3808p AD=0.2128p
+ PS=2.92u PD=1.5u
M$1035 \$144 CLK \$145 VDD sg13_lv_pmos L=0.13u W=1.12u AS=0.2128p AD=0.2128p
+ PS=1.5u PD=1.5u
M$1036 \$145 \$140 \$146 VDD sg13_lv_pmos L=0.13u W=1.12u AS=0.2128p AD=0.2128p
+ PS=1.5u PD=1.5u
M$1037 \$146 \$147 VDD VDD sg13_lv_pmos L=0.13u W=1.12u AS=0.2128p AD=0.3808p
+ PS=1.5u PD=2.92u
M$1038 VDD \$145 \$147 VDD sg13_lv_pmos L=0.13u W=1.12u AS=0.3808p AD=0.2128p
+ PS=2.92u PD=1.5u
M$1039 \$147 \$140 \$148 VDD sg13_lv_pmos L=0.13u W=1.12u AS=0.2128p AD=0.2128p
+ PS=1.5u PD=1.5u
M$1040 \$148 CLK \$149 VDD sg13_lv_pmos L=0.13u W=1.12u AS=0.2128p AD=0.2128p
+ PS=1.5u PD=1.5u
M$1041 \$149 \$150 VDD VDD sg13_lv_pmos L=0.13u W=1.12u AS=0.2128p AD=0.3808p
+ PS=1.5u PD=2.92u
M$1042 VDD \$148 \$150 VDD sg13_lv_pmos L=0.13u W=1.12u AS=0.3808p AD=0.3808p
+ PS=2.92u PD=2.92u
M$1043 VDD \$150 \$151 VDD sg13_lv_pmos L=0.13u W=1.12u AS=0.3808p AD=0.3808p
+ PS=2.92u PD=2.92u
M$1044 VDD CLK \$140 VDD sg13_lv_pmos L=0.13u W=1.12u AS=0.3808p AD=0.3808p
+ PS=2.92u PD=2.92u
M$1045 VDD \$100 \$161 VDD sg13_lv_pmos L=0.13u W=1.12u AS=0.3808p AD=0.3808p
+ PS=2.92u PD=2.92u
M$1046 \$194 \$151 VDD VDD sg13_lv_pmos L=0.13u W=1.12u AS=0.3808p AD=0.2128p
+ PS=2.92u PD=1.5u
M$1047 VDD \$141 \$195 VDD sg13_lv_pmos L=0.13u W=1.12u AS=0.2128p AD=0.2128p
+ PS=1.5u PD=1.5u
M$1048 \$195 \$100 \$163 VDD sg13_lv_pmos L=0.13u W=1.12u AS=0.2128p AD=0.2128p
+ PS=1.5u PD=1.5u
M$1049 \$163 \$161 \$194 VDD sg13_lv_pmos L=0.13u W=1.12u AS=0.2128p AD=0.3808p
+ PS=1.5u PD=2.92u
M$1050 VDD \$163 \$164 VDD sg13_lv_pmos L=0.13u W=1.12u AS=0.3808p AD=0.3808p
+ PS=2.92u PD=2.92u
M$1051 VDD \$164 \$152 VDD sg13_lv_pmos L=0.13u W=1.12u AS=0.3808p AD=0.2128p
+ PS=2.92u PD=1.5u
M$1052 \$152 CLK \$153 VDD sg13_lv_pmos L=0.13u W=1.12u AS=0.2128p AD=0.2128p
+ PS=1.5u PD=1.5u
M$1053 \$153 \$142 \$154 VDD sg13_lv_pmos L=0.13u W=1.12u AS=0.2128p AD=0.2128p
+ PS=1.5u PD=1.5u
M$1054 \$154 \$155 VDD VDD sg13_lv_pmos L=0.13u W=1.12u AS=0.2128p AD=0.3808p
+ PS=1.5u PD=2.92u
M$1055 VDD \$153 \$155 VDD sg13_lv_pmos L=0.13u W=1.12u AS=0.3808p AD=0.2128p
+ PS=2.92u PD=1.5u
M$1056 \$155 \$142 \$156 VDD sg13_lv_pmos L=0.13u W=1.12u AS=0.2128p AD=0.2128p
+ PS=1.5u PD=1.5u
M$1057 \$156 CLK \$157 VDD sg13_lv_pmos L=0.13u W=1.12u AS=0.2128p AD=0.2128p
+ PS=1.5u PD=1.5u
M$1058 \$157 \$158 VDD VDD sg13_lv_pmos L=0.13u W=1.12u AS=0.2128p AD=0.3808p
+ PS=1.5u PD=2.92u
M$1059 VDD \$156 \$158 VDD sg13_lv_pmos L=0.13u W=1.12u AS=0.3808p AD=0.3808p
+ PS=2.92u PD=2.92u
M$1060 VDD \$158 \$33 VDD sg13_lv_pmos L=0.13u W=1.12u AS=0.3808p AD=0.3808p
+ PS=2.92u PD=2.92u
M$1061 VDD CLK \$142 VDD sg13_lv_pmos L=0.13u W=1.12u AS=0.3808p AD=0.3808p
+ PS=2.92u PD=2.92u
M$1062 VDD \$238 \$255 VDD sg13_lv_pmos L=0.13u W=1.12u AS=0.3808p AD=0.3808p
+ PS=2.92u PD=2.92u
M$1063 \$238 \$255 VDD VDD sg13_lv_pmos L=0.13u W=1.12u AS=0.3808p AD=0.3808p
+ PS=2.92u PD=2.92u
M$1064 VDD \$240 \$260 VDD sg13_lv_pmos L=0.13u W=1.12u AS=0.3808p AD=0.3808p
+ PS=2.92u PD=2.92u
M$1065 \$240 \$260 VDD VDD sg13_lv_pmos L=0.13u W=1.12u AS=0.3808p AD=0.3808p
+ PS=2.92u PD=2.92u
M$1066 VDD \$241 \$265 VDD sg13_lv_pmos L=0.13u W=1.12u AS=0.3808p AD=0.3808p
+ PS=2.92u PD=2.92u
M$1067 \$241 \$265 VDD VDD sg13_lv_pmos L=0.13u W=1.12u AS=0.3808p AD=0.3808p
+ PS=2.92u PD=2.92u
M$1068 VDD \$242 \$270 VDD sg13_lv_pmos L=0.13u W=1.12u AS=0.3808p AD=0.3808p
+ PS=2.92u PD=2.92u
M$1069 \$242 \$270 VDD VDD sg13_lv_pmos L=0.13u W=1.12u AS=0.3808p AD=0.3808p
+ PS=2.92u PD=2.92u
M$1070 VDD \$243 \$275 VDD sg13_lv_pmos L=0.13u W=1.12u AS=0.3808p AD=0.3808p
+ PS=2.92u PD=2.92u
M$1071 \$243 \$275 VDD VDD sg13_lv_pmos L=0.13u W=1.12u AS=0.3808p AD=0.3808p
+ PS=2.92u PD=2.92u
M$1072 VDD \$244 \$280 VDD sg13_lv_pmos L=0.13u W=1.12u AS=0.3808p AD=0.3808p
+ PS=2.92u PD=2.92u
M$1073 \$244 \$280 VDD VDD sg13_lv_pmos L=0.13u W=1.12u AS=0.3808p AD=0.3808p
+ PS=2.92u PD=2.92u
M$1074 VDD \$245 \$285 VDD sg13_lv_pmos L=0.13u W=1.12u AS=0.3808p AD=0.3808p
+ PS=2.92u PD=2.92u
M$1075 \$245 \$285 VDD VDD sg13_lv_pmos L=0.13u W=1.12u AS=0.3808p AD=0.3808p
+ PS=2.92u PD=2.92u
M$1076 VDD \$246 \$290 VDD sg13_lv_pmos L=0.13u W=1.12u AS=0.3808p AD=0.3808p
+ PS=2.92u PD=2.92u
M$1077 \$246 \$290 VDD VDD sg13_lv_pmos L=0.13u W=1.12u AS=0.3808p AD=0.3808p
+ PS=2.92u PD=2.92u
M$1078 \$239 PC VDD VDD sg13_lv_pmos L=0.13u W=2.24u AS=0.7616p AD=0.7616p
+ PS=5.16u PD=5.16u
M$1079 \$385 C VDD VDD sg13_lv_pmos L=0.13u W=1.12u AS=0.3808p AD=0.5012p
+ PS=2.92u PD=2.015u
M$1080 VDD B \$385 VDD sg13_lv_pmos L=0.13u W=1.12u AS=0.5012p AD=0.5012p
+ PS=2.015u PD=2.015u
M$1081 \$385 A VDD VDD sg13_lv_pmos L=0.13u W=1.12u AS=0.5012p AD=0.3808p
+ PS=2.015u PD=2.92u
M$1082 \$247 \$385 VDD VDD sg13_lv_pmos L=0.13u W=1.12u AS=0.3808p AD=0.3808p
+ PS=2.92u PD=2.92u
M$1083 VDD \$229 \$386 VDD sg13_lv_pmos L=0.13u W=1.12u AS=0.3808p AD=0.2128p
+ PS=2.92u PD=1.5u
M$1084 \$386 CLK \$387 VDD sg13_lv_pmos L=0.13u W=1.12u AS=0.2128p AD=0.2128p
+ PS=1.5u PD=1.5u
M$1085 \$387 \$360 \$388 VDD sg13_lv_pmos L=0.13u W=1.12u AS=0.2128p AD=0.2128p
+ PS=1.5u PD=1.5u
M$1086 \$388 \$389 VDD VDD sg13_lv_pmos L=0.13u W=1.12u AS=0.2128p AD=0.3808p
+ PS=1.5u PD=2.92u
M$1087 VDD \$387 \$389 VDD sg13_lv_pmos L=0.13u W=1.12u AS=0.3808p AD=0.2128p
+ PS=2.92u PD=1.5u
M$1088 \$389 \$360 \$390 VDD sg13_lv_pmos L=0.13u W=1.12u AS=0.2128p AD=0.2128p
+ PS=1.5u PD=1.5u
M$1089 \$390 CLK \$391 VDD sg13_lv_pmos L=0.13u W=1.12u AS=0.2128p AD=0.2128p
+ PS=1.5u PD=1.5u
M$1090 \$391 \$392 VDD VDD sg13_lv_pmos L=0.13u W=1.12u AS=0.2128p AD=0.3808p
+ PS=1.5u PD=2.92u
M$1091 VDD \$390 \$392 VDD sg13_lv_pmos L=0.13u W=1.12u AS=0.3808p AD=0.3808p
+ PS=2.92u PD=2.92u
M$1092 VDD \$392 \$393 VDD sg13_lv_pmos L=0.13u W=1.12u AS=0.3808p AD=0.3808p
+ PS=2.92u PD=2.92u
M$1093 VDD CLK \$360 VDD sg13_lv_pmos L=0.13u W=1.12u AS=0.3808p AD=0.3808p
+ PS=2.92u PD=2.92u
M$1094 VDD \$100 \$404 VDD sg13_lv_pmos L=0.13u W=1.12u AS=0.3808p AD=0.3808p
+ PS=2.92u PD=2.92u
M$1095 \$451 \$393 VDD VDD sg13_lv_pmos L=0.13u W=1.12u AS=0.3808p AD=0.2128p
+ PS=2.92u PD=1.5u
M$1096 VDD \$361 \$452 VDD sg13_lv_pmos L=0.13u W=1.12u AS=0.2128p AD=0.2128p
+ PS=1.5u PD=1.5u
M$1097 \$452 \$100 \$406 VDD sg13_lv_pmos L=0.13u W=1.12u AS=0.2128p AD=0.2128p
+ PS=1.5u PD=1.5u
M$1098 \$406 \$404 \$451 VDD sg13_lv_pmos L=0.13u W=1.12u AS=0.2128p AD=0.3808p
+ PS=1.5u PD=2.92u
M$1099 VDD \$406 \$407 VDD sg13_lv_pmos L=0.13u W=1.12u AS=0.3808p AD=0.3808p
+ PS=2.92u PD=2.92u
M$1100 VDD \$407 \$395 VDD sg13_lv_pmos L=0.13u W=1.12u AS=0.3808p AD=0.2128p
+ PS=2.92u PD=1.5u
M$1101 \$395 CLK \$396 VDD sg13_lv_pmos L=0.13u W=1.12u AS=0.2128p AD=0.2128p
+ PS=1.5u PD=1.5u
M$1102 \$396 \$362 \$397 VDD sg13_lv_pmos L=0.13u W=1.12u AS=0.2128p AD=0.2128p
+ PS=1.5u PD=1.5u
M$1103 \$397 \$398 VDD VDD sg13_lv_pmos L=0.13u W=1.12u AS=0.2128p AD=0.3808p
+ PS=1.5u PD=2.92u
M$1104 VDD \$396 \$398 VDD sg13_lv_pmos L=0.13u W=1.12u AS=0.3808p AD=0.2128p
+ PS=2.92u PD=1.5u
M$1105 \$398 \$362 \$399 VDD sg13_lv_pmos L=0.13u W=1.12u AS=0.2128p AD=0.2128p
+ PS=1.5u PD=1.5u
M$1106 \$399 CLK \$400 VDD sg13_lv_pmos L=0.13u W=1.12u AS=0.2128p AD=0.2128p
+ PS=1.5u PD=1.5u
M$1107 \$400 \$401 VDD VDD sg13_lv_pmos L=0.13u W=1.12u AS=0.2128p AD=0.3808p
+ PS=1.5u PD=2.92u
M$1108 VDD \$399 \$401 VDD sg13_lv_pmos L=0.13u W=1.12u AS=0.3808p AD=0.3808p
+ PS=2.92u PD=2.92u
M$1109 VDD \$401 \$141 VDD sg13_lv_pmos L=0.13u W=1.12u AS=0.3808p AD=0.3808p
+ PS=2.92u PD=2.92u
M$1110 VDD CLK \$362 VDD sg13_lv_pmos L=0.13u W=1.12u AS=0.3808p AD=0.3808p
+ PS=2.92u PD=2.92u
M$1111 \$483 \$573 VDD VDD sg13_lv_pmos L=0.13u W=1.12u AS=0.3808p AD=0.3808p
+ PS=2.92u PD=2.92u
M$1112 \$573 \$572 VDD VDD sg13_lv_pmos L=0.13u W=1.12u AS=0.3808p AD=0.5012p
+ PS=2.92u PD=2.015u
M$1113 VDD B \$573 VDD sg13_lv_pmos L=0.13u W=1.12u AS=0.5012p AD=0.5012p
+ PS=2.015u PD=2.015u
M$1114 \$573 A VDD VDD sg13_lv_pmos L=0.13u W=1.12u AS=0.5012p AD=0.3808p
+ PS=2.015u PD=2.92u
M$1115 VDD \$442 \$484 VDD sg13_lv_pmos L=0.13u W=1.12u AS=0.3808p AD=0.3808p
+ PS=2.92u PD=2.92u
M$1116 \$442 \$484 VDD VDD sg13_lv_pmos L=0.13u W=1.12u AS=0.3808p AD=0.3808p
+ PS=2.92u PD=2.92u
M$1117 VDD \$444 \$487 VDD sg13_lv_pmos L=0.13u W=1.12u AS=0.3808p AD=0.3808p
+ PS=2.92u PD=2.92u
M$1118 \$444 \$487 VDD VDD sg13_lv_pmos L=0.13u W=1.12u AS=0.3808p AD=0.3808p
+ PS=2.92u PD=2.92u
M$1119 VDD \$445 \$490 VDD sg13_lv_pmos L=0.13u W=1.12u AS=0.3808p AD=0.3808p
+ PS=2.92u PD=2.92u
M$1120 \$445 \$490 VDD VDD sg13_lv_pmos L=0.13u W=1.12u AS=0.3808p AD=0.3808p
+ PS=2.92u PD=2.92u
M$1121 VDD \$446 \$493 VDD sg13_lv_pmos L=0.13u W=1.12u AS=0.3808p AD=0.3808p
+ PS=2.92u PD=2.92u
M$1122 \$446 \$493 VDD VDD sg13_lv_pmos L=0.13u W=1.12u AS=0.3808p AD=0.3808p
+ PS=2.92u PD=2.92u
M$1123 VDD \$447 \$496 VDD sg13_lv_pmos L=0.13u W=1.12u AS=0.3808p AD=0.3808p
+ PS=2.92u PD=2.92u
M$1124 \$447 \$496 VDD VDD sg13_lv_pmos L=0.13u W=1.12u AS=0.3808p AD=0.3808p
+ PS=2.92u PD=2.92u
M$1125 VDD \$448 \$499 VDD sg13_lv_pmos L=0.13u W=1.12u AS=0.3808p AD=0.3808p
+ PS=2.92u PD=2.92u
M$1126 \$448 \$499 VDD VDD sg13_lv_pmos L=0.13u W=1.12u AS=0.3808p AD=0.3808p
+ PS=2.92u PD=2.92u
M$1127 VDD \$449 \$502 VDD sg13_lv_pmos L=0.13u W=1.12u AS=0.3808p AD=0.3808p
+ PS=2.92u PD=2.92u
M$1128 \$449 \$502 VDD VDD sg13_lv_pmos L=0.13u W=1.12u AS=0.3808p AD=0.3808p
+ PS=2.92u PD=2.92u
M$1129 VDD \$450 \$505 VDD sg13_lv_pmos L=0.13u W=1.12u AS=0.3808p AD=0.3808p
+ PS=2.92u PD=2.92u
M$1130 \$450 \$505 VDD VDD sg13_lv_pmos L=0.13u W=1.12u AS=0.3808p AD=0.3808p
+ PS=2.92u PD=2.92u
M$1131 \$443 PC VDD VDD sg13_lv_pmos L=0.13u W=2.24u AS=0.7616p AD=0.7616p
+ PS=5.16u PD=5.16u
M$1132 VDD Veval \$601 VDD sg13_lv_pmos L=0.13u W=1.12u AS=0.3808p AD=0.3808p
+ PS=2.92u PD=2.92u
M$1133 VDD \$601 \$574 VDD sg13_lv_pmos L=0.13u W=4.48u AS=1.5232p AD=1.5232p
+ PS=9.64u PD=9.64u
M$1134 VDD \$574 \$575 VDD sg13_lv_pmos L=0.13u W=1.12u AS=0.3808p AD=0.3808p
+ PS=2.92u PD=2.92u
M$1135 VDD \$575 \$576 VDD sg13_lv_pmos L=0.13u W=4.48u AS=1.5232p AD=1.5232p
+ PS=9.64u PD=9.64u
M$1136 \$845 \$576 \$602 VDD sg13_lv_pmos L=0.13u W=1.12u AS=0.3808p AD=0.3808p
+ PS=2.92u PD=2.92u
M$1137 VDD \$602 \$603 VDD sg13_lv_pmos L=0.13u W=1.12u AS=0.3808p AD=0.3808p
+ PS=2.92u PD=2.92u
M$1138 VDD \$603 \$604 VDD sg13_lv_pmos L=0.13u W=1.12u AS=0.3808p AD=0.3808p
+ PS=2.92u PD=2.92u
M$1139 \$602 \$575 \$605 VDD sg13_lv_pmos L=0.13u W=1.12u AS=0.3808p AD=0.3808p
+ PS=2.92u PD=2.92u
M$1140 \$605 \$603 VDD VDD sg13_lv_pmos L=0.13u W=1.12u AS=0.3808p AD=0.3808p
+ PS=2.92u PD=2.92u
M$1141 VDD \$604 \$630 VDD sg13_lv_pmos L=0.13u W=1.12u AS=0.3808p AD=0.2128p
+ PS=2.92u PD=1.5u
M$1142 \$630 CLK \$631 VDD sg13_lv_pmos L=0.13u W=1.12u AS=0.2128p AD=0.2128p
+ PS=1.5u PD=1.5u
M$1143 \$631 \$606 \$632 VDD sg13_lv_pmos L=0.13u W=1.12u AS=0.2128p AD=0.2128p
+ PS=1.5u PD=1.5u
M$1144 \$632 \$633 VDD VDD sg13_lv_pmos L=0.13u W=1.12u AS=0.2128p AD=0.3808p
+ PS=1.5u PD=2.92u
M$1145 VDD \$631 \$633 VDD sg13_lv_pmos L=0.13u W=1.12u AS=0.3808p AD=0.2128p
+ PS=2.92u PD=1.5u
M$1146 \$633 \$606 \$634 VDD sg13_lv_pmos L=0.13u W=1.12u AS=0.2128p AD=0.2128p
+ PS=1.5u PD=1.5u
M$1147 \$634 CLK \$635 VDD sg13_lv_pmos L=0.13u W=1.12u AS=0.2128p AD=0.2128p
+ PS=1.5u PD=1.5u
M$1148 \$635 \$636 VDD VDD sg13_lv_pmos L=0.13u W=1.12u AS=0.2128p AD=0.3808p
+ PS=1.5u PD=2.92u
M$1149 VDD \$634 \$636 VDD sg13_lv_pmos L=0.13u W=1.12u AS=0.3808p AD=0.3808p
+ PS=2.92u PD=2.92u
M$1150 VDD \$636 \$637 VDD sg13_lv_pmos L=0.13u W=1.12u AS=0.3808p AD=0.3808p
+ PS=2.92u PD=2.92u
M$1151 VDD CLK \$606 VDD sg13_lv_pmos L=0.13u W=1.12u AS=0.3808p AD=0.3808p
+ PS=2.92u PD=2.92u
M$1152 VDD \$100 \$655 VDD sg13_lv_pmos L=0.13u W=1.12u AS=0.3808p AD=0.3808p
+ PS=2.92u PD=2.92u
M$1153 \$718 \$637 VDD VDD sg13_lv_pmos L=0.13u W=1.12u AS=0.3808p AD=0.2128p
+ PS=2.92u PD=1.5u
M$1154 VDD \$607 \$719 VDD sg13_lv_pmos L=0.13u W=1.12u AS=0.2128p AD=0.2128p
+ PS=1.5u PD=1.5u
M$1155 \$719 \$100 \$657 VDD sg13_lv_pmos L=0.13u W=1.12u AS=0.2128p AD=0.2128p
+ PS=1.5u PD=1.5u
M$1156 \$657 \$655 \$718 VDD sg13_lv_pmos L=0.13u W=1.12u AS=0.2128p AD=0.3808p
+ PS=1.5u PD=2.92u
M$1157 VDD \$657 \$658 VDD sg13_lv_pmos L=0.13u W=1.12u AS=0.3808p AD=0.3808p
+ PS=2.92u PD=2.92u
M$1158 VDD \$658 \$638 VDD sg13_lv_pmos L=0.13u W=1.12u AS=0.3808p AD=0.2128p
+ PS=2.92u PD=1.5u
M$1159 \$638 CLK \$639 VDD sg13_lv_pmos L=0.13u W=1.12u AS=0.2128p AD=0.2128p
+ PS=1.5u PD=1.5u
M$1160 \$639 \$608 \$640 VDD sg13_lv_pmos L=0.13u W=1.12u AS=0.2128p AD=0.2128p
+ PS=1.5u PD=1.5u
M$1161 \$640 \$641 VDD VDD sg13_lv_pmos L=0.13u W=1.12u AS=0.2128p AD=0.3808p
+ PS=1.5u PD=2.92u
M$1162 VDD \$639 \$641 VDD sg13_lv_pmos L=0.13u W=1.12u AS=0.3808p AD=0.2128p
+ PS=2.92u PD=1.5u
M$1163 \$641 \$608 \$642 VDD sg13_lv_pmos L=0.13u W=1.12u AS=0.2128p AD=0.2128p
+ PS=1.5u PD=1.5u
M$1164 \$642 CLK \$643 VDD sg13_lv_pmos L=0.13u W=1.12u AS=0.2128p AD=0.2128p
+ PS=1.5u PD=1.5u
M$1165 \$643 \$644 VDD VDD sg13_lv_pmos L=0.13u W=1.12u AS=0.2128p AD=0.3808p
+ PS=1.5u PD=2.92u
M$1166 VDD \$642 \$644 VDD sg13_lv_pmos L=0.13u W=1.12u AS=0.3808p AD=0.3808p
+ PS=2.92u PD=2.92u
M$1167 VDD \$644 \$361 VDD sg13_lv_pmos L=0.13u W=1.12u AS=0.3808p AD=0.3808p
+ PS=2.92u PD=2.92u
M$1168 VDD CLK \$608 VDD sg13_lv_pmos L=0.13u W=1.12u AS=0.3808p AD=0.3808p
+ PS=2.92u PD=2.92u
M$1169 \$843 \$856 VDD VDD sg13_lv_pmos L=0.13u W=1.12u AS=0.3808p AD=0.3808p
+ PS=2.92u PD=2.92u
M$1170 \$788 C VDD VDD sg13_lv_pmos L=0.13u W=1.12u AS=0.3808p AD=0.5012p
+ PS=2.92u PD=2.015u
M$1171 VDD \$786 \$788 VDD sg13_lv_pmos L=0.13u W=1.12u AS=0.5012p AD=0.5012p
+ PS=2.015u PD=2.015u
M$1172 \$788 A VDD VDD sg13_lv_pmos L=0.13u W=1.12u AS=0.5012p AD=0.3808p
+ PS=2.015u PD=2.92u
M$1173 \$645 \$788 VDD VDD sg13_lv_pmos L=0.13u W=1.12u AS=0.3808p AD=0.3808p
+ PS=2.92u PD=2.92u
M$1174 VDD \$646 \$694 VDD sg13_lv_pmos L=0.13u W=1.12u AS=0.3808p AD=0.3808p
+ PS=2.92u PD=2.92u
M$1175 VDD \$844 \$863 VDD sg13_lv_pmos L=0.13u W=1.12u AS=0.3808p AD=0.3808p
+ PS=2.92u PD=2.92u
M$1176 \$844 \$863 VDD VDD sg13_lv_pmos L=0.13u W=1.12u AS=0.3808p AD=0.3808p
+ PS=2.92u PD=2.92u
M$1177 \$646 \$694 VDD VDD sg13_lv_pmos L=0.13u W=1.12u AS=0.3808p AD=0.3808p
+ PS=2.92u PD=2.92u
M$1178 VDD \$648 \$697 VDD sg13_lv_pmos L=0.13u W=1.12u AS=0.3808p AD=0.3808p
+ PS=2.92u PD=2.92u
M$1179 VDD \$846 \$866 VDD sg13_lv_pmos L=0.13u W=1.12u AS=0.3808p AD=0.3808p
+ PS=2.92u PD=2.92u
M$1180 \$846 \$866 VDD VDD sg13_lv_pmos L=0.13u W=1.12u AS=0.3808p AD=0.3808p
+ PS=2.92u PD=2.92u
M$1181 \$648 \$697 VDD VDD sg13_lv_pmos L=0.13u W=1.12u AS=0.3808p AD=0.3808p
+ PS=2.92u PD=2.92u
M$1182 VDD \$649 \$700 VDD sg13_lv_pmos L=0.13u W=1.12u AS=0.3808p AD=0.3808p
+ PS=2.92u PD=2.92u
M$1183 VDD \$847 \$869 VDD sg13_lv_pmos L=0.13u W=1.12u AS=0.3808p AD=0.3808p
+ PS=2.92u PD=2.92u
M$1184 \$847 \$869 VDD VDD sg13_lv_pmos L=0.13u W=1.12u AS=0.3808p AD=0.3808p
+ PS=2.92u PD=2.92u
M$1185 \$649 \$700 VDD VDD sg13_lv_pmos L=0.13u W=1.12u AS=0.3808p AD=0.3808p
+ PS=2.92u PD=2.92u
M$1186 VDD \$848 \$872 VDD sg13_lv_pmos L=0.13u W=1.12u AS=0.3808p AD=0.3808p
+ PS=2.92u PD=2.92u
M$1187 VDD \$650 \$703 VDD sg13_lv_pmos L=0.13u W=1.12u AS=0.3808p AD=0.3808p
+ PS=2.92u PD=2.92u
M$1188 \$848 \$872 VDD VDD sg13_lv_pmos L=0.13u W=1.12u AS=0.3808p AD=0.3808p
+ PS=2.92u PD=2.92u
M$1189 \$650 \$703 VDD VDD sg13_lv_pmos L=0.13u W=1.12u AS=0.3808p AD=0.3808p
+ PS=2.92u PD=2.92u
M$1190 VDD \$651 \$706 VDD sg13_lv_pmos L=0.13u W=1.12u AS=0.3808p AD=0.3808p
+ PS=2.92u PD=2.92u
M$1191 VDD \$849 \$875 VDD sg13_lv_pmos L=0.13u W=1.12u AS=0.3808p AD=0.3808p
+ PS=2.92u PD=2.92u
M$1192 \$651 \$706 VDD VDD sg13_lv_pmos L=0.13u W=1.12u AS=0.3808p AD=0.3808p
+ PS=2.92u PD=2.92u
M$1193 \$849 \$875 VDD VDD sg13_lv_pmos L=0.13u W=1.12u AS=0.3808p AD=0.3808p
+ PS=2.92u PD=2.92u
M$1194 VDD \$850 \$878 VDD sg13_lv_pmos L=0.13u W=1.12u AS=0.3808p AD=0.3808p
+ PS=2.92u PD=2.92u
M$1195 VDD \$652 \$709 VDD sg13_lv_pmos L=0.13u W=1.12u AS=0.3808p AD=0.3808p
+ PS=2.92u PD=2.92u
M$1196 \$850 \$878 VDD VDD sg13_lv_pmos L=0.13u W=1.12u AS=0.3808p AD=0.3808p
+ PS=2.92u PD=2.92u
M$1197 \$652 \$709 VDD VDD sg13_lv_pmos L=0.13u W=1.12u AS=0.3808p AD=0.3808p
+ PS=2.92u PD=2.92u
M$1198 VDD \$851 \$881 VDD sg13_lv_pmos L=0.13u W=1.12u AS=0.3808p AD=0.3808p
+ PS=2.92u PD=2.92u
M$1199 VDD \$653 \$712 VDD sg13_lv_pmos L=0.13u W=1.12u AS=0.3808p AD=0.3808p
+ PS=2.92u PD=2.92u
M$1200 \$653 \$712 VDD VDD sg13_lv_pmos L=0.13u W=1.12u AS=0.3808p AD=0.3808p
+ PS=2.92u PD=2.92u
M$1201 \$851 \$881 VDD VDD sg13_lv_pmos L=0.13u W=1.12u AS=0.3808p AD=0.3808p
+ PS=2.92u PD=2.92u
M$1202 VDD \$654 \$715 VDD sg13_lv_pmos L=0.13u W=1.12u AS=0.3808p AD=0.3808p
+ PS=2.92u PD=2.92u
M$1203 VDD \$852 \$884 VDD sg13_lv_pmos L=0.13u W=1.12u AS=0.3808p AD=0.3808p
+ PS=2.92u PD=2.92u
M$1204 \$852 \$884 VDD VDD sg13_lv_pmos L=0.13u W=1.12u AS=0.3808p AD=0.3808p
+ PS=2.92u PD=2.92u
M$1205 \$654 \$715 VDD VDD sg13_lv_pmos L=0.13u W=1.12u AS=0.3808p AD=0.3808p
+ PS=2.92u PD=2.92u
M$1206 \$845 PC VDD VDD sg13_lv_pmos L=0.13u W=2.24u AS=0.7616p AD=0.7616p
+ PS=5.16u PD=5.16u
M$1207 \$647 PC VDD VDD sg13_lv_pmos L=0.13u W=2.24u AS=0.7616p AD=0.7616p
+ PS=5.16u PD=5.16u
M$1208 VDD \$1010 \$887 VDD sg13_lv_pmos L=0.13u W=1.12u AS=0.3808p AD=0.2128p
+ PS=2.92u PD=1.5u
M$1209 \$887 CLK \$888 VDD sg13_lv_pmos L=0.13u W=1.12u AS=0.2128p AD=0.2128p
+ PS=1.5u PD=1.5u
M$1210 \$888 \$853 \$889 VDD sg13_lv_pmos L=0.13u W=1.12u AS=0.2128p AD=0.2128p
+ PS=1.5u PD=1.5u
M$1211 \$889 \$890 VDD VDD sg13_lv_pmos L=0.13u W=1.12u AS=0.2128p AD=0.3808p
+ PS=1.5u PD=2.92u
M$1212 VDD \$888 \$890 VDD sg13_lv_pmos L=0.13u W=1.12u AS=0.3808p AD=0.2128p
+ PS=2.92u PD=1.5u
M$1213 \$890 \$853 \$891 VDD sg13_lv_pmos L=0.13u W=1.12u AS=0.2128p AD=0.2128p
+ PS=1.5u PD=1.5u
M$1214 \$891 CLK \$892 VDD sg13_lv_pmos L=0.13u W=1.12u AS=0.2128p AD=0.2128p
+ PS=1.5u PD=1.5u
M$1215 \$892 \$893 VDD VDD sg13_lv_pmos L=0.13u W=1.12u AS=0.2128p AD=0.3808p
+ PS=1.5u PD=2.92u
M$1216 VDD \$891 \$893 VDD sg13_lv_pmos L=0.13u W=1.12u AS=0.3808p AD=0.3808p
+ PS=2.92u PD=2.92u
M$1217 VDD \$893 \$894 VDD sg13_lv_pmos L=0.13u W=1.12u AS=0.3808p AD=0.3808p
+ PS=2.92u PD=2.92u
M$1218 VDD CLK \$853 VDD sg13_lv_pmos L=0.13u W=1.12u AS=0.3808p AD=0.3808p
+ PS=2.92u PD=2.92u
M$1219 VDD \$100 \$968 VDD sg13_lv_pmos L=0.13u W=1.12u AS=0.3808p AD=0.3808p
+ PS=2.92u PD=2.92u
M$1220 \$1037 \$894 VDD VDD sg13_lv_pmos L=0.13u W=1.12u AS=0.3808p AD=0.2128p
+ PS=2.92u PD=1.5u
M$1221 VDD \$854 \$1038 VDD sg13_lv_pmos L=0.13u W=1.12u AS=0.2128p AD=0.2128p
+ PS=1.5u PD=1.5u
M$1222 \$1038 \$100 \$970 VDD sg13_lv_pmos L=0.13u W=1.12u AS=0.2128p
+ AD=0.2128p PS=1.5u PD=1.5u
M$1223 \$970 \$968 \$1037 VDD sg13_lv_pmos L=0.13u W=1.12u AS=0.2128p
+ AD=0.3808p PS=1.5u PD=2.92u
M$1224 VDD \$970 \$971 VDD sg13_lv_pmos L=0.13u W=1.12u AS=0.3808p AD=0.3808p
+ PS=2.92u PD=2.92u
M$1225 VDD \$971 \$896 VDD sg13_lv_pmos L=0.13u W=1.12u AS=0.3808p AD=0.2128p
+ PS=2.92u PD=1.5u
M$1226 \$896 CLK \$897 VDD sg13_lv_pmos L=0.13u W=1.12u AS=0.2128p AD=0.2128p
+ PS=1.5u PD=1.5u
M$1227 \$897 \$855 \$898 VDD sg13_lv_pmos L=0.13u W=1.12u AS=0.2128p AD=0.2128p
+ PS=1.5u PD=1.5u
M$1228 \$898 \$899 VDD VDD sg13_lv_pmos L=0.13u W=1.12u AS=0.2128p AD=0.3808p
+ PS=1.5u PD=2.92u
M$1229 VDD \$897 \$899 VDD sg13_lv_pmos L=0.13u W=1.12u AS=0.3808p AD=0.2128p
+ PS=2.92u PD=1.5u
M$1230 \$899 \$855 \$900 VDD sg13_lv_pmos L=0.13u W=1.12u AS=0.2128p AD=0.2128p
+ PS=1.5u PD=1.5u
M$1231 \$900 CLK \$901 VDD sg13_lv_pmos L=0.13u W=1.12u AS=0.2128p AD=0.2128p
+ PS=1.5u PD=1.5u
M$1232 \$901 \$902 VDD VDD sg13_lv_pmos L=0.13u W=1.12u AS=0.2128p AD=0.3808p
+ PS=1.5u PD=2.92u
M$1233 VDD \$900 \$902 VDD sg13_lv_pmos L=0.13u W=1.12u AS=0.3808p AD=0.3808p
+ PS=2.92u PD=2.92u
M$1234 VDD \$902 \$607 VDD sg13_lv_pmos L=0.13u W=1.12u AS=0.3808p AD=0.3808p
+ PS=2.92u PD=2.92u
M$1235 VDD CLK \$855 VDD sg13_lv_pmos L=0.13u W=1.12u AS=0.3808p AD=0.3808p
+ PS=2.92u PD=2.92u
M$1236 \$856 \$572 VDD VDD sg13_lv_pmos L=0.13u W=1.12u AS=0.3808p AD=0.5012p
+ PS=2.92u PD=2.015u
M$1237 VDD \$786 \$856 VDD sg13_lv_pmos L=0.13u W=1.12u AS=0.5012p AD=0.5012p
+ PS=2.015u PD=2.015u
M$1238 \$856 A VDD VDD sg13_lv_pmos L=0.13u W=1.12u AS=0.5012p AD=0.3808p
+ PS=2.015u PD=2.92u
M$1239 \$1075 \$1096 VDD VDD sg13_lv_pmos L=0.13u W=1.12u AS=0.3808p AD=0.3808p
+ PS=2.92u PD=2.92u
M$1240 \$1096 C VDD VDD sg13_lv_pmos L=0.13u W=1.12u AS=0.3808p AD=0.5012p
+ PS=2.92u PD=2.015u
M$1241 VDD B \$1096 VDD sg13_lv_pmos L=0.13u W=1.12u AS=0.5012p AD=0.5012p
+ PS=2.015u PD=2.015u
M$1242 \$1096 \$1188 VDD VDD sg13_lv_pmos L=0.13u W=1.12u AS=0.5012p AD=0.3808p
+ PS=2.015u PD=2.92u
M$1243 VDD \$1084 \$1097 VDD sg13_lv_pmos L=0.13u W=1.12u AS=0.3808p AD=0.3808p
+ PS=2.92u PD=2.92u
M$1244 \$1084 \$1097 VDD VDD sg13_lv_pmos L=0.13u W=1.12u AS=0.3808p AD=0.3808p
+ PS=2.92u PD=2.92u
M$1245 VDD \$1085 \$1100 VDD sg13_lv_pmos L=0.13u W=1.12u AS=0.3808p AD=0.3808p
+ PS=2.92u PD=2.92u
M$1246 \$1085 \$1100 VDD VDD sg13_lv_pmos L=0.13u W=1.12u AS=0.3808p AD=0.3808p
+ PS=2.92u PD=2.92u
M$1247 VDD \$1086 \$1103 VDD sg13_lv_pmos L=0.13u W=1.12u AS=0.3808p AD=0.3808p
+ PS=2.92u PD=2.92u
M$1248 \$1086 \$1103 VDD VDD sg13_lv_pmos L=0.13u W=1.12u AS=0.3808p AD=0.3808p
+ PS=2.92u PD=2.92u
M$1249 VDD \$1087 \$1106 VDD sg13_lv_pmos L=0.13u W=1.12u AS=0.3808p AD=0.3808p
+ PS=2.92u PD=2.92u
M$1250 \$1087 \$1106 VDD VDD sg13_lv_pmos L=0.13u W=1.12u AS=0.3808p AD=0.3808p
+ PS=2.92u PD=2.92u
M$1251 VDD \$1088 \$1109 VDD sg13_lv_pmos L=0.13u W=1.12u AS=0.3808p AD=0.3808p
+ PS=2.92u PD=2.92u
M$1252 \$1088 \$1109 VDD VDD sg13_lv_pmos L=0.13u W=1.12u AS=0.3808p AD=0.3808p
+ PS=2.92u PD=2.92u
M$1253 VDD \$1089 \$1112 VDD sg13_lv_pmos L=0.13u W=1.12u AS=0.3808p AD=0.3808p
+ PS=2.92u PD=2.92u
M$1254 \$1089 \$1112 VDD VDD sg13_lv_pmos L=0.13u W=1.12u AS=0.3808p AD=0.3808p
+ PS=2.92u PD=2.92u
M$1255 VDD \$1090 \$1115 VDD sg13_lv_pmos L=0.13u W=1.12u AS=0.3808p AD=0.3808p
+ PS=2.92u PD=2.92u
M$1256 \$1090 \$1115 VDD VDD sg13_lv_pmos L=0.13u W=1.12u AS=0.3808p AD=0.3808p
+ PS=2.92u PD=2.92u
M$1257 VDD \$1091 \$1118 VDD sg13_lv_pmos L=0.13u W=1.12u AS=0.3808p AD=0.3808p
+ PS=2.92u PD=2.92u
M$1258 \$1091 \$1118 VDD VDD sg13_lv_pmos L=0.13u W=1.12u AS=0.3808p AD=0.3808p
+ PS=2.92u PD=2.92u
M$1259 \$1083 PC VDD VDD sg13_lv_pmos L=0.13u W=2.24u AS=0.7616p AD=0.7616p
+ PS=5.16u PD=5.16u
M$1260 VDD Veval \$1007 VDD sg13_lv_pmos L=0.13u W=1.12u AS=0.3808p AD=0.3808p
+ PS=2.92u PD=2.92u
M$1261 VDD \$1007 \$857 VDD sg13_lv_pmos L=0.13u W=4.48u AS=1.5232p AD=1.5232p
+ PS=9.64u PD=9.64u
M$1262 VDD \$857 \$967 VDD sg13_lv_pmos L=0.13u W=1.12u AS=0.3808p AD=0.3808p
+ PS=2.92u PD=2.92u
M$1263 VDD \$967 \$858 VDD sg13_lv_pmos L=0.13u W=4.48u AS=1.5232p AD=1.5232p
+ PS=9.64u PD=9.64u
M$1264 \$1083 \$858 \$1008 VDD sg13_lv_pmos L=0.13u W=1.12u AS=0.3808p
+ AD=0.3808p PS=2.92u PD=2.92u
M$1265 VDD \$1008 \$1009 VDD sg13_lv_pmos L=0.13u W=1.12u AS=0.3808p AD=0.3808p
+ PS=2.92u PD=2.92u
M$1266 VDD \$1009 \$1010 VDD sg13_lv_pmos L=0.13u W=1.12u AS=0.3808p AD=0.3808p
+ PS=2.92u PD=2.92u
M$1267 \$1008 \$967 \$1011 VDD sg13_lv_pmos L=0.13u W=1.12u AS=0.3808p
+ AD=0.3808p PS=2.92u PD=2.92u
M$1268 \$1011 \$1009 VDD VDD sg13_lv_pmos L=0.13u W=1.12u AS=0.3808p AD=0.3808p
+ PS=2.92u PD=2.92u
M$1269 VDD \$1408 \$1214 VDD sg13_lv_pmos L=0.13u W=1.12u AS=0.3808p AD=0.2128p
+ PS=2.92u PD=1.5u
M$1270 \$1214 CLK \$1215 VDD sg13_lv_pmos L=0.13u W=1.12u AS=0.2128p AD=0.2128p
+ PS=1.5u PD=1.5u
M$1271 \$1215 \$1121 \$1216 VDD sg13_lv_pmos L=0.13u W=1.12u AS=0.2128p
+ AD=0.2128p PS=1.5u PD=1.5u
M$1272 \$1216 \$1217 VDD VDD sg13_lv_pmos L=0.13u W=1.12u AS=0.2128p AD=0.3808p
+ PS=1.5u PD=2.92u
M$1273 VDD \$1215 \$1217 VDD sg13_lv_pmos L=0.13u W=1.12u AS=0.3808p AD=0.2128p
+ PS=2.92u PD=1.5u
M$1274 \$1217 \$1121 \$1218 VDD sg13_lv_pmos L=0.13u W=1.12u AS=0.2128p
+ AD=0.2128p PS=1.5u PD=1.5u
M$1275 \$1218 CLK \$1219 VDD sg13_lv_pmos L=0.13u W=1.12u AS=0.2128p AD=0.2128p
+ PS=1.5u PD=1.5u
M$1276 \$1219 \$1220 VDD VDD sg13_lv_pmos L=0.13u W=1.12u AS=0.2128p AD=0.3808p
+ PS=1.5u PD=2.92u
M$1277 VDD \$1218 \$1220 VDD sg13_lv_pmos L=0.13u W=1.12u AS=0.3808p AD=0.3808p
+ PS=2.92u PD=2.92u
M$1278 VDD \$1220 \$1221 VDD sg13_lv_pmos L=0.13u W=1.12u AS=0.3808p AD=0.3808p
+ PS=2.92u PD=2.92u
M$1279 VDD CLK \$1121 VDD sg13_lv_pmos L=0.13u W=1.12u AS=0.3808p AD=0.3808p
+ PS=2.92u PD=2.92u
M$1280 VDD \$100 \$1222 VDD sg13_lv_pmos L=0.13u W=1.12u AS=0.3808p AD=0.3808p
+ PS=2.92u PD=2.92u
M$1281 \$1264 \$1221 VDD VDD sg13_lv_pmos L=0.13u W=1.12u AS=0.3808p AD=0.2128p
+ PS=2.92u PD=1.5u
M$1282 VDD \$1122 \$1265 VDD sg13_lv_pmos L=0.13u W=1.12u AS=0.2128p AD=0.2128p
+ PS=1.5u PD=1.5u
M$1283 \$1265 \$100 \$1224 VDD sg13_lv_pmos L=0.13u W=1.12u AS=0.2128p
+ AD=0.2128p PS=1.5u PD=1.5u
M$1284 \$1224 \$1222 \$1264 VDD sg13_lv_pmos L=0.13u W=1.12u AS=0.2128p
+ AD=0.3808p PS=1.5u PD=2.92u
M$1285 VDD \$1224 \$1225 VDD sg13_lv_pmos L=0.13u W=1.12u AS=0.3808p AD=0.3808p
+ PS=2.92u PD=2.92u
M$1286 VDD \$1225 \$1226 VDD sg13_lv_pmos L=0.13u W=1.12u AS=0.3808p AD=0.2128p
+ PS=2.92u PD=1.5u
M$1287 \$1226 CLK \$1227 VDD sg13_lv_pmos L=0.13u W=1.12u AS=0.2128p AD=0.2128p
+ PS=1.5u PD=1.5u
M$1288 \$1227 \$1123 \$1228 VDD sg13_lv_pmos L=0.13u W=1.12u AS=0.2128p
+ AD=0.2128p PS=1.5u PD=1.5u
M$1289 \$1228 \$1229 VDD VDD sg13_lv_pmos L=0.13u W=1.12u AS=0.2128p AD=0.3808p
+ PS=1.5u PD=2.92u
M$1290 VDD \$1227 \$1229 VDD sg13_lv_pmos L=0.13u W=1.12u AS=0.3808p AD=0.2128p
+ PS=2.92u PD=1.5u
M$1291 \$1229 \$1123 \$1230 VDD sg13_lv_pmos L=0.13u W=1.12u AS=0.2128p
+ AD=0.2128p PS=1.5u PD=1.5u
M$1292 \$1230 CLK \$1231 VDD sg13_lv_pmos L=0.13u W=1.12u AS=0.2128p AD=0.2128p
+ PS=1.5u PD=1.5u
M$1293 \$1231 \$1232 VDD VDD sg13_lv_pmos L=0.13u W=1.12u AS=0.2128p AD=0.3808p
+ PS=1.5u PD=2.92u
M$1294 VDD \$1230 \$1232 VDD sg13_lv_pmos L=0.13u W=1.12u AS=0.3808p AD=0.3808p
+ PS=2.92u PD=2.92u
M$1295 VDD \$1232 \$854 VDD sg13_lv_pmos L=0.13u W=1.12u AS=0.3808p AD=0.3808p
+ PS=2.92u PD=2.92u
M$1296 VDD CLK \$1123 VDD sg13_lv_pmos L=0.13u W=1.12u AS=0.3808p AD=0.3808p
+ PS=2.92u PD=2.92u
M$1297 \$1263 \$572 VDD VDD sg13_lv_pmos L=0.13u W=1.12u AS=0.3808p AD=0.5012p
+ PS=2.92u PD=2.015u
M$1298 VDD B \$1263 VDD sg13_lv_pmos L=0.13u W=1.12u AS=0.5012p AD=0.5012p
+ PS=2.015u PD=2.015u
M$1299 \$1263 \$1188 VDD VDD sg13_lv_pmos L=0.13u W=1.12u AS=0.5012p AD=0.3808p
+ PS=2.015u PD=2.92u
M$1300 \$1213 \$1263 VDD VDD sg13_lv_pmos L=0.13u W=1.12u AS=0.3808p AD=0.3808p
+ PS=2.92u PD=2.92u
M$1301 VDD \$1294 \$1313 VDD sg13_lv_pmos L=0.13u W=1.12u AS=0.3808p AD=0.3808p
+ PS=2.92u PD=2.92u
M$1302 \$1294 \$1313 VDD VDD sg13_lv_pmos L=0.13u W=1.12u AS=0.3808p AD=0.3808p
+ PS=2.92u PD=2.92u
M$1303 VDD \$1296 \$1316 VDD sg13_lv_pmos L=0.13u W=1.12u AS=0.3808p AD=0.3808p
+ PS=2.92u PD=2.92u
M$1304 \$1296 \$1316 VDD VDD sg13_lv_pmos L=0.13u W=1.12u AS=0.3808p AD=0.3808p
+ PS=2.92u PD=2.92u
M$1305 VDD \$1297 \$1319 VDD sg13_lv_pmos L=0.13u W=1.12u AS=0.3808p AD=0.3808p
+ PS=2.92u PD=2.92u
M$1306 \$1297 \$1319 VDD VDD sg13_lv_pmos L=0.13u W=1.12u AS=0.3808p AD=0.3808p
+ PS=2.92u PD=2.92u
M$1307 VDD \$1298 \$1322 VDD sg13_lv_pmos L=0.13u W=1.12u AS=0.3808p AD=0.3808p
+ PS=2.92u PD=2.92u
M$1308 \$1298 \$1322 VDD VDD sg13_lv_pmos L=0.13u W=1.12u AS=0.3808p AD=0.3808p
+ PS=2.92u PD=2.92u
M$1309 VDD \$1299 \$1325 VDD sg13_lv_pmos L=0.13u W=1.12u AS=0.3808p AD=0.3808p
+ PS=2.92u PD=2.92u
M$1310 \$1299 \$1325 VDD VDD sg13_lv_pmos L=0.13u W=1.12u AS=0.3808p AD=0.3808p
+ PS=2.92u PD=2.92u
M$1311 VDD \$1300 \$1328 VDD sg13_lv_pmos L=0.13u W=1.12u AS=0.3808p AD=0.3808p
+ PS=2.92u PD=2.92u
M$1312 \$1300 \$1328 VDD VDD sg13_lv_pmos L=0.13u W=1.12u AS=0.3808p AD=0.3808p
+ PS=2.92u PD=2.92u
M$1313 VDD \$1301 \$1331 VDD sg13_lv_pmos L=0.13u W=1.12u AS=0.3808p AD=0.3808p
+ PS=2.92u PD=2.92u
M$1314 \$1301 \$1331 VDD VDD sg13_lv_pmos L=0.13u W=1.12u AS=0.3808p AD=0.3808p
+ PS=2.92u PD=2.92u
M$1315 VDD \$1302 \$1334 VDD sg13_lv_pmos L=0.13u W=1.12u AS=0.3808p AD=0.3808p
+ PS=2.92u PD=2.92u
M$1316 \$1302 \$1334 VDD VDD sg13_lv_pmos L=0.13u W=1.12u AS=0.3808p AD=0.3808p
+ PS=2.92u PD=2.92u
M$1317 \$1295 PC VDD VDD sg13_lv_pmos L=0.13u W=2.24u AS=0.7616p AD=0.7616p
+ PS=5.16u PD=5.16u
M$1318 VDD Veval \$1405 VDD sg13_lv_pmos L=0.13u W=1.12u AS=0.3808p AD=0.3808p
+ PS=2.92u PD=2.92u
M$1319 VDD \$1405 \$1303 VDD sg13_lv_pmos L=0.13u W=4.48u AS=1.5232p AD=1.5232p
+ PS=9.64u PD=9.64u
M$1320 VDD \$1303 \$1337 VDD sg13_lv_pmos L=0.13u W=1.12u AS=0.3808p AD=0.3808p
+ PS=2.92u PD=2.92u
M$1321 VDD \$1337 \$1304 VDD sg13_lv_pmos L=0.13u W=4.48u AS=1.5232p AD=1.5232p
+ PS=9.64u PD=9.64u
M$1322 \$1295 \$1304 \$1406 VDD sg13_lv_pmos L=0.13u W=1.12u AS=0.3808p
+ AD=0.3808p PS=2.92u PD=2.92u
M$1323 VDD \$1406 \$1407 VDD sg13_lv_pmos L=0.13u W=1.12u AS=0.3808p AD=0.3808p
+ PS=2.92u PD=2.92u
M$1324 VDD \$1407 \$1408 VDD sg13_lv_pmos L=0.13u W=1.12u AS=0.3808p AD=0.3808p
+ PS=2.92u PD=2.92u
M$1325 \$1406 \$1337 \$1409 VDD sg13_lv_pmos L=0.13u W=1.12u AS=0.3808p
+ AD=0.3808p PS=2.92u PD=2.92u
M$1326 \$1409 \$1407 VDD VDD sg13_lv_pmos L=0.13u W=1.12u AS=0.3808p AD=0.3808p
+ PS=2.92u PD=2.92u
M$1327 VDD C \$572 VDD sg13_lv_pmos L=0.13u W=1.12u AS=0.3808p AD=0.3808p
+ PS=2.92u PD=2.92u
M$1328 \$1442 \$1453 VDD VDD sg13_lv_pmos L=0.13u W=1.12u AS=0.3808p AD=0.3808p
+ PS=2.92u PD=2.92u
M$1329 VDD \$1700 \$1454 VDD sg13_lv_pmos L=0.13u W=1.12u AS=0.3808p AD=0.2128p
+ PS=2.92u PD=1.5u
M$1330 \$1454 CLK \$1455 VDD sg13_lv_pmos L=0.13u W=1.12u AS=0.2128p AD=0.2128p
+ PS=1.5u PD=1.5u
M$1331 \$1455 \$1443 \$1456 VDD sg13_lv_pmos L=0.13u W=1.12u AS=0.2128p
+ AD=0.2128p PS=1.5u PD=1.5u
M$1332 \$1456 \$1457 VDD VDD sg13_lv_pmos L=0.13u W=1.12u AS=0.2128p AD=0.3808p
+ PS=1.5u PD=2.92u
M$1333 VDD \$1455 \$1457 VDD sg13_lv_pmos L=0.13u W=1.12u AS=0.3808p AD=0.2128p
+ PS=2.92u PD=1.5u
M$1334 \$1457 \$1443 \$1458 VDD sg13_lv_pmos L=0.13u W=1.12u AS=0.2128p
+ AD=0.2128p PS=1.5u PD=1.5u
M$1335 \$1458 CLK \$1459 VDD sg13_lv_pmos L=0.13u W=1.12u AS=0.2128p AD=0.2128p
+ PS=1.5u PD=1.5u
M$1336 \$1459 \$1460 VDD VDD sg13_lv_pmos L=0.13u W=1.12u AS=0.2128p AD=0.3808p
+ PS=1.5u PD=2.92u
M$1337 VDD \$1458 \$1460 VDD sg13_lv_pmos L=0.13u W=1.12u AS=0.3808p AD=0.3808p
+ PS=2.92u PD=2.92u
M$1338 VDD \$1460 \$1461 VDD sg13_lv_pmos L=0.13u W=1.12u AS=0.3808p AD=0.3808p
+ PS=2.92u PD=2.92u
M$1339 VDD CLK \$1443 VDD sg13_lv_pmos L=0.13u W=1.12u AS=0.3808p AD=0.3808p
+ PS=2.92u PD=2.92u
M$1340 VDD \$100 \$1474 VDD sg13_lv_pmos L=0.13u W=1.12u AS=0.3808p AD=0.3808p
+ PS=2.92u PD=2.92u
M$1341 \$1519 \$1461 VDD VDD sg13_lv_pmos L=0.13u W=1.12u AS=0.3808p AD=0.2128p
+ PS=2.92u PD=1.5u
M$1342 VDD \$1410 \$1520 VDD sg13_lv_pmos L=0.13u W=1.12u AS=0.2128p AD=0.2128p
+ PS=1.5u PD=1.5u
M$1343 \$1520 \$100 \$1476 VDD sg13_lv_pmos L=0.13u W=1.12u AS=0.2128p
+ AD=0.2128p PS=1.5u PD=1.5u
M$1344 \$1476 \$1474 \$1519 VDD sg13_lv_pmos L=0.13u W=1.12u AS=0.2128p
+ AD=0.3808p PS=1.5u PD=2.92u
M$1345 VDD \$1476 \$1477 VDD sg13_lv_pmos L=0.13u W=1.12u AS=0.3808p AD=0.3808p
+ PS=2.92u PD=2.92u
M$1346 VDD \$1477 \$1462 VDD sg13_lv_pmos L=0.13u W=1.12u AS=0.3808p AD=0.2128p
+ PS=2.92u PD=1.5u
M$1347 \$1462 CLK \$1463 VDD sg13_lv_pmos L=0.13u W=1.12u AS=0.2128p AD=0.2128p
+ PS=1.5u PD=1.5u
M$1348 \$1463 \$1444 \$1464 VDD sg13_lv_pmos L=0.13u W=1.12u AS=0.2128p
+ AD=0.2128p PS=1.5u PD=1.5u
M$1349 \$1464 \$1465 VDD VDD sg13_lv_pmos L=0.13u W=1.12u AS=0.2128p AD=0.3808p
+ PS=1.5u PD=2.92u
M$1350 VDD \$1463 \$1465 VDD sg13_lv_pmos L=0.13u W=1.12u AS=0.3808p AD=0.2128p
+ PS=2.92u PD=1.5u
M$1351 \$1465 \$1444 \$1466 VDD sg13_lv_pmos L=0.13u W=1.12u AS=0.2128p
+ AD=0.2128p PS=1.5u PD=1.5u
M$1352 \$1466 CLK \$1467 VDD sg13_lv_pmos L=0.13u W=1.12u AS=0.2128p AD=0.2128p
+ PS=1.5u PD=1.5u
M$1353 \$1467 \$1468 VDD VDD sg13_lv_pmos L=0.13u W=1.12u AS=0.2128p AD=0.3808p
+ PS=1.5u PD=2.92u
M$1354 VDD \$1466 \$1468 VDD sg13_lv_pmos L=0.13u W=1.12u AS=0.3808p AD=0.3808p
+ PS=2.92u PD=2.92u
M$1355 VDD \$1468 \$1122 VDD sg13_lv_pmos L=0.13u W=1.12u AS=0.3808p AD=0.3808p
+ PS=2.92u PD=2.92u
M$1356 VDD CLK \$1444 VDD sg13_lv_pmos L=0.13u W=1.12u AS=0.3808p AD=0.3808p
+ PS=2.92u PD=2.92u
M$1357 VDD B \$786 VDD sg13_lv_pmos L=0.13u W=1.12u AS=0.3808p AD=0.3808p
+ PS=2.92u PD=2.92u
M$1358 VDD A \$1188 VDD sg13_lv_pmos L=0.13u W=1.12u AS=0.3808p AD=0.3808p
+ PS=2.92u PD=2.92u
M$1359 \$1643 \$1662 VDD VDD sg13_lv_pmos L=0.13u W=1.12u AS=0.3808p AD=0.3808p
+ PS=2.92u PD=2.92u
M$1360 \$1662 \$572 VDD VDD sg13_lv_pmos L=0.13u W=1.12u AS=0.3808p AD=0.5012p
+ PS=2.92u PD=2.015u
M$1361 VDD \$786 \$1662 VDD sg13_lv_pmos L=0.13u W=1.12u AS=0.5012p AD=0.5012p
+ PS=2.015u PD=2.015u
M$1362 \$1662 \$1188 VDD VDD sg13_lv_pmos L=0.13u W=1.12u AS=0.5012p AD=0.3808p
+ PS=2.015u PD=2.92u
M$1363 \$1453 C VDD VDD sg13_lv_pmos L=0.13u W=1.12u AS=0.3808p AD=0.5012p
+ PS=2.92u PD=2.015u
M$1364 VDD \$786 \$1453 VDD sg13_lv_pmos L=0.13u W=1.12u AS=0.5012p AD=0.5012p
+ PS=2.015u PD=2.015u
M$1365 \$1453 \$1188 VDD VDD sg13_lv_pmos L=0.13u W=1.12u AS=0.5012p AD=0.3808p
+ PS=2.015u PD=2.92u
M$1366 VDD \$1508 \$1521 VDD sg13_lv_pmos L=0.13u W=1.12u AS=0.3808p AD=0.3808p
+ PS=2.92u PD=2.92u
M$1367 \$1508 \$1521 VDD VDD sg13_lv_pmos L=0.13u W=1.12u AS=0.3808p AD=0.3808p
+ PS=2.92u PD=2.92u
M$1368 VDD \$1509 \$1524 VDD sg13_lv_pmos L=0.13u W=1.12u AS=0.3808p AD=0.3808p
+ PS=2.92u PD=2.92u
M$1369 \$1509 \$1524 VDD VDD sg13_lv_pmos L=0.13u W=1.12u AS=0.3808p AD=0.3808p
+ PS=2.92u PD=2.92u
M$1370 VDD \$1510 \$1527 VDD sg13_lv_pmos L=0.13u W=1.12u AS=0.3808p AD=0.3808p
+ PS=2.92u PD=2.92u
M$1371 \$1510 \$1527 VDD VDD sg13_lv_pmos L=0.13u W=1.12u AS=0.3808p AD=0.3808p
+ PS=2.92u PD=2.92u
M$1372 VDD \$1511 \$1530 VDD sg13_lv_pmos L=0.13u W=1.12u AS=0.3808p AD=0.3808p
+ PS=2.92u PD=2.92u
M$1373 \$1511 \$1530 VDD VDD sg13_lv_pmos L=0.13u W=1.12u AS=0.3808p AD=0.3808p
+ PS=2.92u PD=2.92u
M$1374 VDD \$1512 \$1533 VDD sg13_lv_pmos L=0.13u W=1.12u AS=0.3808p AD=0.3808p
+ PS=2.92u PD=2.92u
M$1375 \$1512 \$1533 VDD VDD sg13_lv_pmos L=0.13u W=1.12u AS=0.3808p AD=0.3808p
+ PS=2.92u PD=2.92u
M$1376 VDD \$1513 \$1536 VDD sg13_lv_pmos L=0.13u W=1.12u AS=0.3808p AD=0.3808p
+ PS=2.92u PD=2.92u
M$1377 \$1513 \$1536 VDD VDD sg13_lv_pmos L=0.13u W=1.12u AS=0.3808p AD=0.3808p
+ PS=2.92u PD=2.92u
M$1378 VDD \$1514 \$1539 VDD sg13_lv_pmos L=0.13u W=1.12u AS=0.3808p AD=0.3808p
+ PS=2.92u PD=2.92u
M$1379 \$1514 \$1539 VDD VDD sg13_lv_pmos L=0.13u W=1.12u AS=0.3808p AD=0.3808p
+ PS=2.92u PD=2.92u
M$1380 VDD \$1515 \$1542 VDD sg13_lv_pmos L=0.13u W=1.12u AS=0.3808p AD=0.3808p
+ PS=2.92u PD=2.92u
M$1381 \$1515 \$1542 VDD VDD sg13_lv_pmos L=0.13u W=1.12u AS=0.3808p AD=0.3808p
+ PS=2.92u PD=2.92u
M$1382 \$1677 PC VDD VDD sg13_lv_pmos L=0.13u W=2.24u AS=0.7616p AD=0.7616p
+ PS=5.16u PD=5.16u
M$1383 \$1473 PC VDD VDD sg13_lv_pmos L=0.13u W=2.24u AS=0.7616p AD=0.7616p
+ PS=5.16u PD=5.16u
M$1384 VDD \$1921 \$1702 VDD sg13_lv_pmos L=0.13u W=1.12u AS=0.3808p AD=0.2128p
+ PS=2.92u PD=1.5u
M$1385 \$1702 CLK \$1703 VDD sg13_lv_pmos L=0.13u W=1.12u AS=0.2128p AD=0.2128p
+ PS=1.5u PD=1.5u
M$1386 \$1703 \$1665 \$1704 VDD sg13_lv_pmos L=0.13u W=1.12u AS=0.2128p
+ AD=0.2128p PS=1.5u PD=1.5u
M$1387 \$1704 \$1705 VDD VDD sg13_lv_pmos L=0.13u W=1.12u AS=0.2128p AD=0.3808p
+ PS=1.5u PD=2.92u
M$1388 VDD \$1703 \$1705 VDD sg13_lv_pmos L=0.13u W=1.12u AS=0.3808p AD=0.2128p
+ PS=2.92u PD=1.5u
M$1389 \$1705 \$1665 \$1706 VDD sg13_lv_pmos L=0.13u W=1.12u AS=0.2128p
+ AD=0.2128p PS=1.5u PD=1.5u
M$1390 \$1706 CLK \$1707 VDD sg13_lv_pmos L=0.13u W=1.12u AS=0.2128p AD=0.2128p
+ PS=1.5u PD=1.5u
M$1391 \$1707 \$1708 VDD VDD sg13_lv_pmos L=0.13u W=1.12u AS=0.2128p AD=0.3808p
+ PS=1.5u PD=2.92u
M$1392 VDD \$1706 \$1708 VDD sg13_lv_pmos L=0.13u W=1.12u AS=0.3808p AD=0.3808p
+ PS=2.92u PD=2.92u
M$1393 VDD \$1708 \$1709 VDD sg13_lv_pmos L=0.13u W=1.12u AS=0.3808p AD=0.3808p
+ PS=2.92u PD=2.92u
M$1394 VDD CLK \$1665 VDD sg13_lv_pmos L=0.13u W=1.12u AS=0.3808p AD=0.3808p
+ PS=2.92u PD=2.92u
M$1395 VDD \$100 \$1710 VDD sg13_lv_pmos L=0.13u W=1.12u AS=0.3808p AD=0.3808p
+ PS=2.92u PD=2.92u
M$1396 \$1779 \$1709 VDD VDD sg13_lv_pmos L=0.13u W=1.12u AS=0.3808p AD=0.2128p
+ PS=2.92u PD=1.5u
M$1397 VDD VSS \$1780 VDD sg13_lv_pmos L=0.13u W=1.12u AS=0.2128p AD=0.2128p
+ PS=1.5u PD=1.5u
M$1398 \$1780 \$100 \$1781 VDD sg13_lv_pmos L=0.13u W=1.12u AS=0.2128p
+ AD=0.2128p PS=1.5u PD=1.5u
M$1399 \$1781 \$1710 \$1779 VDD sg13_lv_pmos L=0.13u W=1.12u AS=0.2128p
+ AD=0.3808p PS=1.5u PD=2.92u
M$1400 VDD \$1781 \$1712 VDD sg13_lv_pmos L=0.13u W=1.12u AS=0.3808p AD=0.3808p
+ PS=2.92u PD=2.92u
M$1401 VDD \$1712 \$1713 VDD sg13_lv_pmos L=0.13u W=1.12u AS=0.3808p AD=0.2128p
+ PS=2.92u PD=1.5u
M$1402 \$1713 CLK \$1714 VDD sg13_lv_pmos L=0.13u W=1.12u AS=0.2128p AD=0.2128p
+ PS=1.5u PD=1.5u
M$1403 \$1714 \$1666 \$1715 VDD sg13_lv_pmos L=0.13u W=1.12u AS=0.2128p
+ AD=0.2128p PS=1.5u PD=1.5u
M$1404 \$1715 \$1716 VDD VDD sg13_lv_pmos L=0.13u W=1.12u AS=0.2128p AD=0.3808p
+ PS=1.5u PD=2.92u
M$1405 VDD \$1714 \$1716 VDD sg13_lv_pmos L=0.13u W=1.12u AS=0.3808p AD=0.2128p
+ PS=2.92u PD=1.5u
M$1406 \$1716 \$1666 \$1717 VDD sg13_lv_pmos L=0.13u W=1.12u AS=0.2128p
+ AD=0.2128p PS=1.5u PD=1.5u
M$1407 \$1717 CLK \$1718 VDD sg13_lv_pmos L=0.13u W=1.12u AS=0.2128p AD=0.2128p
+ PS=1.5u PD=1.5u
M$1408 \$1718 \$1719 VDD VDD sg13_lv_pmos L=0.13u W=1.12u AS=0.2128p AD=0.3808p
+ PS=1.5u PD=2.92u
M$1409 VDD \$1717 \$1719 VDD sg13_lv_pmos L=0.13u W=1.12u AS=0.3808p AD=0.3808p
+ PS=2.92u PD=2.92u
M$1410 VDD \$1719 \$1410 VDD sg13_lv_pmos L=0.13u W=1.12u AS=0.3808p AD=0.3808p
+ PS=2.92u PD=2.92u
M$1411 VDD CLK \$1666 VDD sg13_lv_pmos L=0.13u W=1.12u AS=0.3808p AD=0.3808p
+ PS=2.92u PD=2.92u
M$1412 VDD \$1676 \$1742 VDD sg13_lv_pmos L=0.13u W=1.12u AS=0.3808p AD=0.3808p
+ PS=2.92u PD=2.92u
M$1413 \$1676 \$1742 VDD VDD sg13_lv_pmos L=0.13u W=1.12u AS=0.3808p AD=0.3808p
+ PS=2.92u PD=2.92u
M$1414 VDD \$1678 \$1745 VDD sg13_lv_pmos L=0.13u W=1.12u AS=0.3808p AD=0.3808p
+ PS=2.92u PD=2.92u
M$1415 \$1678 \$1745 VDD VDD sg13_lv_pmos L=0.13u W=1.12u AS=0.3808p AD=0.3808p
+ PS=2.92u PD=2.92u
M$1416 VDD \$1679 \$1748 VDD sg13_lv_pmos L=0.13u W=1.12u AS=0.3808p AD=0.3808p
+ PS=2.92u PD=2.92u
M$1417 \$1679 \$1748 VDD VDD sg13_lv_pmos L=0.13u W=1.12u AS=0.3808p AD=0.3808p
+ PS=2.92u PD=2.92u
M$1418 VDD \$1680 \$1751 VDD sg13_lv_pmos L=0.13u W=1.12u AS=0.3808p AD=0.3808p
+ PS=2.92u PD=2.92u
M$1419 \$1680 \$1751 VDD VDD sg13_lv_pmos L=0.13u W=1.12u AS=0.3808p AD=0.3808p
+ PS=2.92u PD=2.92u
M$1420 VDD \$1681 \$1754 VDD sg13_lv_pmos L=0.13u W=1.12u AS=0.3808p AD=0.3808p
+ PS=2.92u PD=2.92u
M$1421 \$1681 \$1754 VDD VDD sg13_lv_pmos L=0.13u W=1.12u AS=0.3808p AD=0.3808p
+ PS=2.92u PD=2.92u
M$1422 VDD \$1682 \$1757 VDD sg13_lv_pmos L=0.13u W=1.12u AS=0.3808p AD=0.3808p
+ PS=2.92u PD=2.92u
M$1423 \$1682 \$1757 VDD VDD sg13_lv_pmos L=0.13u W=1.12u AS=0.3808p AD=0.3808p
+ PS=2.92u PD=2.92u
M$1424 VDD \$1683 \$1760 VDD sg13_lv_pmos L=0.13u W=1.12u AS=0.3808p AD=0.3808p
+ PS=2.92u PD=2.92u
M$1425 \$1683 \$1760 VDD VDD sg13_lv_pmos L=0.13u W=1.12u AS=0.3808p AD=0.3808p
+ PS=2.92u PD=2.92u
M$1426 VDD \$1684 \$1763 VDD sg13_lv_pmos L=0.13u W=1.12u AS=0.3808p AD=0.3808p
+ PS=2.92u PD=2.92u
M$1427 \$1684 \$1763 VDD VDD sg13_lv_pmos L=0.13u W=1.12u AS=0.3808p AD=0.3808p
+ PS=2.92u PD=2.92u
M$1428 VDD Veval \$1697 VDD sg13_lv_pmos L=0.13u W=1.12u AS=0.3808p AD=0.3808p
+ PS=2.92u PD=2.92u
M$1429 VDD \$1697 \$1663 VDD sg13_lv_pmos L=0.13u W=4.48u AS=1.5232p AD=1.5232p
+ PS=9.64u PD=9.64u
M$1430 VDD \$1663 \$1685 VDD sg13_lv_pmos L=0.13u W=1.12u AS=0.3808p AD=0.3808p
+ PS=2.92u PD=2.92u
M$1431 VDD \$1685 \$1664 VDD sg13_lv_pmos L=0.13u W=4.48u AS=1.5232p AD=1.5232p
+ PS=9.64u PD=9.64u
M$1432 \$1473 \$1664 \$1698 VDD sg13_lv_pmos L=0.13u W=1.12u AS=0.3808p
+ AD=0.3808p PS=2.92u PD=2.92u
M$1433 VDD \$1698 \$1699 VDD sg13_lv_pmos L=0.13u W=1.12u AS=0.3808p AD=0.3808p
+ PS=2.92u PD=2.92u
M$1434 VDD \$1699 \$1700 VDD sg13_lv_pmos L=0.13u W=1.12u AS=0.3808p AD=0.3808p
+ PS=2.92u PD=2.92u
M$1435 \$1698 \$1685 \$1701 VDD sg13_lv_pmos L=0.13u W=1.12u AS=0.3808p
+ AD=0.3808p PS=2.92u PD=2.92u
M$1436 \$1701 \$1699 VDD VDD sg13_lv_pmos L=0.13u W=1.12u AS=0.3808p AD=0.3808p
+ PS=2.92u PD=2.92u
M$1437 VDD IN \$1948 VDD sg13_lv_pmos L=0.13u W=1.12u AS=0.3808p AD=0.2128p
+ PS=2.92u PD=1.5u
M$1438 \$1948 \$1945 \$1949 VDD sg13_lv_pmos L=0.13u W=1.12u AS=0.2128p
+ AD=0.2128p PS=1.5u PD=1.5u
M$1439 \$1949 \$1937 \$1950 VDD sg13_lv_pmos L=0.13u W=1.12u AS=0.2128p
+ AD=0.2128p PS=1.5u PD=1.5u
M$1440 \$1950 \$1951 VDD VDD sg13_lv_pmos L=0.13u W=1.12u AS=0.2128p AD=0.3808p
+ PS=1.5u PD=2.92u
M$1441 VDD \$1949 \$1951 VDD sg13_lv_pmos L=0.13u W=1.12u AS=0.3808p AD=0.2128p
+ PS=2.92u PD=1.5u
M$1442 \$1951 \$1937 \$1952 VDD sg13_lv_pmos L=0.13u W=1.12u AS=0.2128p
+ AD=0.2128p PS=1.5u PD=1.5u
M$1443 \$1952 \$1945 \$1953 VDD sg13_lv_pmos L=0.13u W=1.12u AS=0.2128p
+ AD=0.2128p PS=1.5u PD=1.5u
M$1444 \$1953 \$256 VDD VDD sg13_lv_pmos L=0.13u W=1.12u AS=0.2128p AD=0.3808p
+ PS=1.5u PD=2.92u
M$1445 VDD \$1952 \$256 VDD sg13_lv_pmos L=0.13u W=1.12u AS=0.3808p AD=0.3808p
+ PS=2.92u PD=2.92u
M$1446 VDD \$256 \$258 VDD sg13_lv_pmos L=0.13u W=1.12u AS=0.3808p AD=0.3808p
+ PS=2.92u PD=2.92u
M$1447 VDD \$1643 \$1902 VDD sg13_lv_pmos L=0.13u W=1.12u AS=0.3808p AD=0.5012p
+ PS=2.92u PD=2.015u
M$1448 \$1902 EN_DEC VDD VDD sg13_lv_pmos L=0.13u W=1.12u AS=0.5012p AD=0.3808p
+ PS=2.015u PD=2.92u
M$1449 VDD \$1945 \$1937 VDD sg13_lv_pmos L=0.13u W=1.12u AS=0.3808p AD=0.3808p
+ PS=2.92u PD=2.92u
M$1450 VDD \$1902 \$1688 VDD sg13_lv_pmos L=0.13u W=1.12u AS=0.3808p AD=0.3808p
+ PS=2.92u PD=2.92u
M$1451 VDD \$258 \$1954 VDD sg13_lv_pmos L=0.13u W=1.12u AS=0.3808p AD=0.2128p
+ PS=2.92u PD=1.5u
M$1452 \$1954 \$1945 \$1955 VDD sg13_lv_pmos L=0.13u W=1.12u AS=0.2128p
+ AD=0.2128p PS=1.5u PD=1.5u
M$1453 \$1955 \$1938 \$1956 VDD sg13_lv_pmos L=0.13u W=1.12u AS=0.2128p
+ AD=0.2128p PS=1.5u PD=1.5u
M$1454 \$1956 \$1957 VDD VDD sg13_lv_pmos L=0.13u W=1.12u AS=0.2128p AD=0.3808p
+ PS=1.5u PD=2.92u
M$1455 VDD \$1955 \$1957 VDD sg13_lv_pmos L=0.13u W=1.12u AS=0.3808p AD=0.2128p
+ PS=2.92u PD=1.5u
M$1456 \$1957 \$1938 \$1958 VDD sg13_lv_pmos L=0.13u W=1.12u AS=0.2128p
+ AD=0.2128p PS=1.5u PD=1.5u
M$1457 \$1958 \$1945 \$1959 VDD sg13_lv_pmos L=0.13u W=1.12u AS=0.2128p
+ AD=0.2128p PS=1.5u PD=1.5u
M$1458 \$1959 \$261 VDD VDD sg13_lv_pmos L=0.13u W=1.12u AS=0.2128p AD=0.3808p
+ PS=1.5u PD=2.92u
M$1459 VDD \$1958 \$261 VDD sg13_lv_pmos L=0.13u W=1.12u AS=0.3808p AD=0.3808p
+ PS=2.92u PD=2.92u
M$1460 VDD \$261 \$263 VDD sg13_lv_pmos L=0.13u W=1.12u AS=0.3808p AD=0.3808p
+ PS=2.92u PD=2.92u
M$1461 VDD \$1945 \$1938 VDD sg13_lv_pmos L=0.13u W=1.12u AS=0.3808p AD=0.3808p
+ PS=2.92u PD=2.92u
M$1462 VDD \$263 \$1960 VDD sg13_lv_pmos L=0.13u W=1.12u AS=0.3808p AD=0.2128p
+ PS=2.92u PD=1.5u
M$1463 \$1960 \$1945 \$1961 VDD sg13_lv_pmos L=0.13u W=1.12u AS=0.2128p
+ AD=0.2128p PS=1.5u PD=1.5u
M$1464 \$1961 \$1939 \$1962 VDD sg13_lv_pmos L=0.13u W=1.12u AS=0.2128p
+ AD=0.2128p PS=1.5u PD=1.5u
M$1465 \$1962 \$1963 VDD VDD sg13_lv_pmos L=0.13u W=1.12u AS=0.2128p AD=0.3808p
+ PS=1.5u PD=2.92u
M$1466 VDD \$1961 \$1963 VDD sg13_lv_pmos L=0.13u W=1.12u AS=0.3808p AD=0.2128p
+ PS=2.92u PD=1.5u
M$1467 \$1963 \$1939 \$1964 VDD sg13_lv_pmos L=0.13u W=1.12u AS=0.2128p
+ AD=0.2128p PS=1.5u PD=1.5u
M$1468 \$1964 \$1945 \$1965 VDD sg13_lv_pmos L=0.13u W=1.12u AS=0.2128p
+ AD=0.2128p PS=1.5u PD=1.5u
M$1469 \$1965 \$266 VDD VDD sg13_lv_pmos L=0.13u W=1.12u AS=0.2128p AD=0.3808p
+ PS=1.5u PD=2.92u
M$1470 VDD \$1964 \$266 VDD sg13_lv_pmos L=0.13u W=1.12u AS=0.3808p AD=0.3808p
+ PS=2.92u PD=2.92u
M$1471 VDD \$266 \$268 VDD sg13_lv_pmos L=0.13u W=1.12u AS=0.3808p AD=0.3808p
+ PS=2.92u PD=2.92u
M$1472 VDD \$1945 \$1939 VDD sg13_lv_pmos L=0.13u W=1.12u AS=0.3808p AD=0.3808p
+ PS=2.92u PD=2.92u
M$1473 VDD \$268 \$1966 VDD sg13_lv_pmos L=0.13u W=1.12u AS=0.3808p AD=0.2128p
+ PS=2.92u PD=1.5u
M$1474 \$1966 \$1945 \$1967 VDD sg13_lv_pmos L=0.13u W=1.12u AS=0.2128p
+ AD=0.2128p PS=1.5u PD=1.5u
M$1475 \$1967 \$1940 \$1968 VDD sg13_lv_pmos L=0.13u W=1.12u AS=0.2128p
+ AD=0.2128p PS=1.5u PD=1.5u
M$1476 \$1968 \$1969 VDD VDD sg13_lv_pmos L=0.13u W=1.12u AS=0.2128p AD=0.3808p
+ PS=1.5u PD=2.92u
M$1477 VDD \$1967 \$1969 VDD sg13_lv_pmos L=0.13u W=1.12u AS=0.3808p AD=0.2128p
+ PS=2.92u PD=1.5u
M$1478 \$1969 \$1940 \$1970 VDD sg13_lv_pmos L=0.13u W=1.12u AS=0.2128p
+ AD=0.2128p PS=1.5u PD=1.5u
M$1479 \$1970 \$1945 \$1971 VDD sg13_lv_pmos L=0.13u W=1.12u AS=0.2128p
+ AD=0.2128p PS=1.5u PD=1.5u
M$1480 \$1971 \$271 VDD VDD sg13_lv_pmos L=0.13u W=1.12u AS=0.2128p AD=0.3808p
+ PS=1.5u PD=2.92u
M$1481 VDD \$1970 \$271 VDD sg13_lv_pmos L=0.13u W=1.12u AS=0.3808p AD=0.3808p
+ PS=2.92u PD=2.92u
M$1482 VDD \$271 \$273 VDD sg13_lv_pmos L=0.13u W=1.12u AS=0.3808p AD=0.3808p
+ PS=2.92u PD=2.92u
M$1483 VDD \$1945 \$1940 VDD sg13_lv_pmos L=0.13u W=1.12u AS=0.3808p AD=0.3808p
+ PS=2.92u PD=2.92u
M$1484 VDD \$273 \$1972 VDD sg13_lv_pmos L=0.13u W=1.12u AS=0.3808p AD=0.2128p
+ PS=2.92u PD=1.5u
M$1485 \$1972 \$1945 \$1973 VDD sg13_lv_pmos L=0.13u W=1.12u AS=0.2128p
+ AD=0.2128p PS=1.5u PD=1.5u
M$1486 \$1973 \$1941 \$1974 VDD sg13_lv_pmos L=0.13u W=1.12u AS=0.2128p
+ AD=0.2128p PS=1.5u PD=1.5u
M$1487 \$1974 \$1975 VDD VDD sg13_lv_pmos L=0.13u W=1.12u AS=0.2128p AD=0.3808p
+ PS=1.5u PD=2.92u
M$1488 VDD \$1973 \$1975 VDD sg13_lv_pmos L=0.13u W=1.12u AS=0.3808p AD=0.2128p
+ PS=2.92u PD=1.5u
M$1489 \$1975 \$1941 \$1976 VDD sg13_lv_pmos L=0.13u W=1.12u AS=0.2128p
+ AD=0.2128p PS=1.5u PD=1.5u
M$1490 \$1976 \$1945 \$1977 VDD sg13_lv_pmos L=0.13u W=1.12u AS=0.2128p
+ AD=0.2128p PS=1.5u PD=1.5u
M$1491 \$1977 \$276 VDD VDD sg13_lv_pmos L=0.13u W=1.12u AS=0.2128p AD=0.3808p
+ PS=1.5u PD=2.92u
M$1492 VDD \$1976 \$276 VDD sg13_lv_pmos L=0.13u W=1.12u AS=0.3808p AD=0.3808p
+ PS=2.92u PD=2.92u
M$1493 VDD \$276 \$278 VDD sg13_lv_pmos L=0.13u W=1.12u AS=0.3808p AD=0.3808p
+ PS=2.92u PD=2.92u
M$1494 VDD \$1945 \$1941 VDD sg13_lv_pmos L=0.13u W=1.12u AS=0.3808p AD=0.3808p
+ PS=2.92u PD=2.92u
M$1495 VDD \$278 \$1978 VDD sg13_lv_pmos L=0.13u W=1.12u AS=0.3808p AD=0.2128p
+ PS=2.92u PD=1.5u
M$1496 \$1978 \$1945 \$1979 VDD sg13_lv_pmos L=0.13u W=1.12u AS=0.2128p
+ AD=0.2128p PS=1.5u PD=1.5u
M$1497 \$1979 \$1942 \$1980 VDD sg13_lv_pmos L=0.13u W=1.12u AS=0.2128p
+ AD=0.2128p PS=1.5u PD=1.5u
M$1498 \$1980 \$1981 VDD VDD sg13_lv_pmos L=0.13u W=1.12u AS=0.2128p AD=0.3808p
+ PS=1.5u PD=2.92u
M$1499 VDD \$1979 \$1981 VDD sg13_lv_pmos L=0.13u W=1.12u AS=0.3808p AD=0.2128p
+ PS=2.92u PD=1.5u
M$1500 \$1981 \$1942 \$1982 VDD sg13_lv_pmos L=0.13u W=1.12u AS=0.2128p
+ AD=0.2128p PS=1.5u PD=1.5u
M$1501 \$1982 \$1945 \$1983 VDD sg13_lv_pmos L=0.13u W=1.12u AS=0.2128p
+ AD=0.2128p PS=1.5u PD=1.5u
M$1502 \$1983 \$281 VDD VDD sg13_lv_pmos L=0.13u W=1.12u AS=0.2128p AD=0.3808p
+ PS=1.5u PD=2.92u
M$1503 VDD \$1982 \$281 VDD sg13_lv_pmos L=0.13u W=1.12u AS=0.3808p AD=0.3808p
+ PS=2.92u PD=2.92u
M$1504 VDD \$281 \$283 VDD sg13_lv_pmos L=0.13u W=1.12u AS=0.3808p AD=0.3808p
+ PS=2.92u PD=2.92u
M$1505 VDD \$1945 \$1942 VDD sg13_lv_pmos L=0.13u W=1.12u AS=0.3808p AD=0.3808p
+ PS=2.92u PD=2.92u
M$1506 VDD \$283 \$1984 VDD sg13_lv_pmos L=0.13u W=1.12u AS=0.3808p AD=0.2128p
+ PS=2.92u PD=1.5u
M$1507 \$1984 \$1945 \$1985 VDD sg13_lv_pmos L=0.13u W=1.12u AS=0.2128p
+ AD=0.2128p PS=1.5u PD=1.5u
M$1508 \$1985 \$1943 \$1986 VDD sg13_lv_pmos L=0.13u W=1.12u AS=0.2128p
+ AD=0.2128p PS=1.5u PD=1.5u
M$1509 \$1986 \$1987 VDD VDD sg13_lv_pmos L=0.13u W=1.12u AS=0.2128p AD=0.3808p
+ PS=1.5u PD=2.92u
M$1510 VDD \$1985 \$1987 VDD sg13_lv_pmos L=0.13u W=1.12u AS=0.3808p AD=0.2128p
+ PS=2.92u PD=1.5u
M$1511 \$1987 \$1943 \$1988 VDD sg13_lv_pmos L=0.13u W=1.12u AS=0.2128p
+ AD=0.2128p PS=1.5u PD=1.5u
M$1512 \$1988 \$1945 \$1989 VDD sg13_lv_pmos L=0.13u W=1.12u AS=0.2128p
+ AD=0.2128p PS=1.5u PD=1.5u
M$1513 \$1989 \$286 VDD VDD sg13_lv_pmos L=0.13u W=1.12u AS=0.2128p AD=0.3808p
+ PS=1.5u PD=2.92u
M$1514 VDD \$1988 \$286 VDD sg13_lv_pmos L=0.13u W=1.12u AS=0.3808p AD=0.3808p
+ PS=2.92u PD=2.92u
M$1515 VDD \$286 \$288 VDD sg13_lv_pmos L=0.13u W=1.12u AS=0.3808p AD=0.3808p
+ PS=2.92u PD=2.92u
M$1516 VDD \$1945 \$1943 VDD sg13_lv_pmos L=0.13u W=1.12u AS=0.3808p AD=0.3808p
+ PS=2.92u PD=2.92u
M$1517 VDD \$288 \$1990 VDD sg13_lv_pmos L=0.13u W=1.12u AS=0.3808p AD=0.2128p
+ PS=2.92u PD=1.5u
M$1518 \$1990 \$1945 \$1991 VDD sg13_lv_pmos L=0.13u W=1.12u AS=0.2128p
+ AD=0.2128p PS=1.5u PD=1.5u
M$1519 \$1991 \$1944 \$1992 VDD sg13_lv_pmos L=0.13u W=1.12u AS=0.2128p
+ AD=0.2128p PS=1.5u PD=1.5u
M$1520 \$1992 \$1993 VDD VDD sg13_lv_pmos L=0.13u W=1.12u AS=0.2128p AD=0.3808p
+ PS=1.5u PD=2.92u
M$1521 VDD \$1991 \$1993 VDD sg13_lv_pmos L=0.13u W=1.12u AS=0.3808p AD=0.2128p
+ PS=2.92u PD=1.5u
M$1522 \$1993 \$1944 \$1994 VDD sg13_lv_pmos L=0.13u W=1.12u AS=0.2128p
+ AD=0.2128p PS=1.5u PD=1.5u
M$1523 \$1994 \$1945 \$1995 VDD sg13_lv_pmos L=0.13u W=1.12u AS=0.2128p
+ AD=0.2128p PS=1.5u PD=1.5u
M$1524 \$1995 \$291 VDD VDD sg13_lv_pmos L=0.13u W=1.12u AS=0.2128p AD=0.3808p
+ PS=1.5u PD=2.92u
M$1525 VDD \$1994 \$291 VDD sg13_lv_pmos L=0.13u W=1.12u AS=0.3808p AD=0.3808p
+ PS=2.92u PD=2.92u
M$1526 VDD \$291 \$293 VDD sg13_lv_pmos L=0.13u W=1.12u AS=0.3808p AD=0.3808p
+ PS=2.92u PD=2.92u
M$1527 VDD \$1945 \$1944 VDD sg13_lv_pmos L=0.13u W=1.12u AS=0.3808p AD=0.3808p
+ PS=2.92u PD=2.92u
M$1528 VDD Veval \$1918 VDD sg13_lv_pmos L=0.13u W=1.12u AS=0.3808p AD=0.3808p
+ PS=2.92u PD=2.92u
M$1529 VDD \$1918 \$1905 VDD sg13_lv_pmos L=0.13u W=4.48u AS=1.5232p AD=1.5232p
+ PS=9.64u PD=9.64u
M$1530 VDD \$1905 \$1915 VDD sg13_lv_pmos L=0.13u W=1.12u AS=0.3808p AD=0.3808p
+ PS=2.92u PD=2.92u
M$1531 VDD \$1915 \$1906 VDD sg13_lv_pmos L=0.13u W=4.48u AS=1.5232p AD=1.5232p
+ PS=9.64u PD=9.64u
M$1532 \$1677 \$1906 \$1919 VDD sg13_lv_pmos L=0.13u W=1.12u AS=0.3808p
+ AD=0.3808p PS=2.92u PD=2.92u
M$1533 VDD \$1919 \$1920 VDD sg13_lv_pmos L=0.13u W=1.12u AS=0.3808p AD=0.3808p
+ PS=2.92u PD=2.92u
M$1534 VDD \$1920 \$1921 VDD sg13_lv_pmos L=0.13u W=1.12u AS=0.3808p AD=0.3808p
+ PS=2.92u PD=2.92u
M$1535 \$1919 \$1915 \$1922 VDD sg13_lv_pmos L=0.13u W=1.12u AS=0.3808p
+ AD=0.3808p PS=2.92u PD=2.92u
M$1536 \$1922 \$1920 VDD VDD sg13_lv_pmos L=0.13u W=1.12u AS=0.3808p AD=0.3808p
+ PS=2.92u PD=2.92u
M$1537 VDD EN \$2173 VDD sg13_lv_pmos L=0.13u W=1.12u AS=0.3808p AD=0.3808p
+ PS=2.92u PD=2.92u
M$1538 VDD \$2173 \$2371 VDD sg13_lv_pmos L=0.13u W=1.12u AS=0.3808p AD=0.5012p
+ PS=2.92u PD=2.015u
M$1539 \$2371 \$2174 VDD VDD sg13_lv_pmos L=0.13u W=1.12u AS=0.5012p AD=0.3808p
+ PS=2.015u PD=2.92u
M$1540 VDD \$2371 \$2373 VDD sg13_lv_pmos L=0.13u W=1.12u AS=0.3808p AD=0.5012p
+ PS=2.92u PD=2.015u
M$1541 \$2373 CLK VDD VDD sg13_lv_pmos L=0.13u W=1.12u AS=0.5012p AD=0.3808p
+ PS=2.015u PD=2.92u
M$1542 VDD \$2373 \$1945 VDD sg13_lv_pmos L=0.13u W=1.12u AS=0.3808p AD=0.3808p
+ PS=2.92u PD=2.92u
M$1543 VDD \$2182 \$2176 VDD sg13_lv_pmos L=0.13u W=1.12u AS=0.3808p AD=0.2128p
+ PS=2.92u PD=1.5u
M$1544 \$2176 \$1945 \$2177 VDD sg13_lv_pmos L=0.13u W=1.12u AS=0.2128p
+ AD=0.2128p PS=1.5u PD=1.5u
M$1545 \$2177 \$2175 \$2178 VDD sg13_lv_pmos L=0.13u W=1.12u AS=0.2128p
+ AD=0.2128p PS=1.5u PD=1.5u
M$1546 \$2178 \$2179 VDD VDD sg13_lv_pmos L=0.13u W=1.12u AS=0.2128p AD=0.3808p
+ PS=1.5u PD=2.92u
M$1547 VDD \$2177 \$2179 VDD sg13_lv_pmos L=0.13u W=1.12u AS=0.3808p AD=0.2128p
+ PS=2.92u PD=1.5u
M$1548 \$2179 \$2175 \$2180 VDD sg13_lv_pmos L=0.13u W=1.12u AS=0.2128p
+ AD=0.2128p PS=1.5u PD=1.5u
M$1549 \$2180 \$1945 \$2181 VDD sg13_lv_pmos L=0.13u W=1.12u AS=0.2128p
+ AD=0.2128p PS=1.5u PD=1.5u
M$1550 \$2181 \$2182 VDD VDD sg13_lv_pmos L=0.13u W=1.12u AS=0.2128p AD=0.3808p
+ PS=1.5u PD=2.92u
M$1551 VDD \$2180 \$2182 VDD sg13_lv_pmos L=0.13u W=1.12u AS=0.3808p AD=0.3808p
+ PS=2.92u PD=2.92u
M$1552 VDD \$2182 \$2192 VDD sg13_lv_pmos L=0.13u W=1.12u AS=0.3808p AD=0.3808p
+ PS=2.92u PD=2.92u
M$1553 VDD \$1945 \$2175 VDD sg13_lv_pmos L=0.13u W=1.12u AS=0.3808p AD=0.3808p
+ PS=2.92u PD=2.92u
M$1554 VDD \$2429 \$2184 VDD sg13_lv_pmos L=0.13u W=1.12u AS=0.3808p AD=0.2128p
+ PS=2.92u PD=1.5u
M$1555 \$2184 \$2192 \$2185 VDD sg13_lv_pmos L=0.13u W=1.12u AS=0.2128p
+ AD=0.2128p PS=1.5u PD=1.5u
M$1556 \$2185 \$2183 \$2186 VDD sg13_lv_pmos L=0.13u W=1.12u AS=0.2128p
+ AD=0.2128p PS=1.5u PD=1.5u
M$1557 \$2186 \$2187 VDD VDD sg13_lv_pmos L=0.13u W=1.12u AS=0.2128p AD=0.3808p
+ PS=1.5u PD=2.92u
M$1558 VDD \$2185 \$2187 VDD sg13_lv_pmos L=0.13u W=1.12u AS=0.3808p AD=0.2128p
+ PS=2.92u PD=1.5u
M$1559 \$2187 \$2183 \$2188 VDD sg13_lv_pmos L=0.13u W=1.12u AS=0.2128p
+ AD=0.2128p PS=1.5u PD=1.5u
M$1560 \$2188 \$2192 \$2189 VDD sg13_lv_pmos L=0.13u W=1.12u AS=0.2128p
+ AD=0.2128p PS=1.5u PD=1.5u
M$1561 \$2189 \$2429 VDD VDD sg13_lv_pmos L=0.13u W=1.12u AS=0.2128p AD=0.3808p
+ PS=1.5u PD=2.92u
M$1562 VDD \$2188 \$2429 VDD sg13_lv_pmos L=0.13u W=1.12u AS=0.3808p AD=0.3808p
+ PS=2.92u PD=2.92u
M$1563 VDD \$2429 \$2191 VDD sg13_lv_pmos L=0.13u W=1.12u AS=0.3808p AD=0.3808p
+ PS=2.92u PD=2.92u
M$1564 VDD \$2192 \$2183 VDD sg13_lv_pmos L=0.13u W=1.12u AS=0.3808p AD=0.3808p
+ PS=2.92u PD=2.92u
M$1565 VDD \$2380 \$2374 VDD sg13_lv_pmos L=0.13u W=1.12u AS=0.3808p AD=0.2128p
+ PS=2.92u PD=1.5u
M$1566 \$2374 \$2191 \$2375 VDD sg13_lv_pmos L=0.13u W=1.12u AS=0.2128p
+ AD=0.2128p PS=1.5u PD=1.5u
M$1567 \$2375 \$2190 \$2376 VDD sg13_lv_pmos L=0.13u W=1.12u AS=0.2128p
+ AD=0.2128p PS=1.5u PD=1.5u
M$1568 \$2376 \$2377 VDD VDD sg13_lv_pmos L=0.13u W=1.12u AS=0.2128p AD=0.3808p
+ PS=1.5u PD=2.92u
M$1569 VDD \$2375 \$2377 VDD sg13_lv_pmos L=0.13u W=1.12u AS=0.3808p AD=0.2128p
+ PS=2.92u PD=1.5u
M$1570 \$2377 \$2190 \$2378 VDD sg13_lv_pmos L=0.13u W=1.12u AS=0.2128p
+ AD=0.2128p PS=1.5u PD=1.5u
M$1571 \$2378 \$2191 \$2379 VDD sg13_lv_pmos L=0.13u W=1.12u AS=0.2128p
+ AD=0.2128p PS=1.5u PD=1.5u
M$1572 \$2379 \$2380 VDD VDD sg13_lv_pmos L=0.13u W=1.12u AS=0.2128p AD=0.3808p
+ PS=1.5u PD=2.92u
M$1573 VDD \$2378 \$2380 VDD sg13_lv_pmos L=0.13u W=1.12u AS=0.3808p AD=0.3808p
+ PS=2.92u PD=2.92u
M$1574 VDD \$2380 \$2381 VDD sg13_lv_pmos L=0.13u W=1.12u AS=0.3808p AD=0.3808p
+ PS=2.92u PD=2.92u
M$1575 VDD \$2191 \$2190 VDD sg13_lv_pmos L=0.13u W=1.12u AS=0.3808p AD=0.3808p
+ PS=2.92u PD=2.92u
M$1576 VDD \$2381 \$2382 VDD sg13_lv_pmos L=0.13u W=1.12u AS=0.3808p AD=0.2128p
+ PS=2.92u PD=1.5u
M$1577 \$2382 \$2191 VDD VDD sg13_lv_pmos L=0.13u W=1.12u AS=0.2128p AD=0.2128p
+ PS=1.5u PD=1.5u
M$1578 VDD \$2192 \$2382 VDD sg13_lv_pmos L=0.13u W=1.12u AS=0.2128p AD=0.3808p
+ PS=1.5u PD=2.92u
M$1579 VDD \$2382 \$2174 VDD sg13_lv_pmos L=0.13u W=1.12u AS=0.3808p AD=0.3808p
+ PS=2.92u PD=2.92u
M$1580 VDD EN \$100 VDD sg13_lv_pmos L=0.13u W=1.12u AS=0.3808p AD=0.3808p
+ PS=2.92u PD=2.92u
.ENDS TOP_XPCAM
